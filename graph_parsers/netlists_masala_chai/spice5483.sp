plaintext
* NMOS Transistor
M1 4 2 5 5 NMOS

* Voltage Source
VDD 3 0 DC 15

* Resistors
RD 3 4 1k
RG 2 0 10Meg
RS 5 0 220

.end
