plaintext
* Differential Amplifier

* Voltage Sources
VCC 7 0 DC 12V
VEE 8 0 DC -12V

* Resistors
RC 6 7 3k
RE 5 8 5k

* NPN Transistors
Q1 2 1 3 NPN
Q2 6 2 4 NPN

* End of Netlist
