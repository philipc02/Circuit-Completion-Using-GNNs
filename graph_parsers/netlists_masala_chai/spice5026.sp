spice
* Example SPICE Netlist
Vin 5 3 AC 1
R1 5 2 R
C1 2 3 C
.END
