spice
* PMOS Transistors
M_P1 6 8 10 10 PMOS
M_P2 9 2 10 10 PMOS
M_P3 7 3 10 10 PMOS

* NMOS Transistors
M_N1 6 11 2 2 NMOS
M_N2 9 6 3 3 NMOS
M_N3 7 9 3 3 NMOS

* Voltage Source
VDD 10 0 DC 5V
