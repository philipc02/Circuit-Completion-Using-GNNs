plaintext
* NMOS Common Source Amplifier
M1 2 3 7 7 NMOS
V1 3 0 DC Vi
RS 7 0 RS
RD 2 6 RD
