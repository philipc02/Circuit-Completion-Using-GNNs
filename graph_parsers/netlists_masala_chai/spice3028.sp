spice
* Nodes identified based on red annotations

M1 2 4 2 2 NMOS
M2 7 4 9 9 NMOS
M3 2 2 1 1 PMOS
M4 2 2 8 8 PMOS
M5 7 2 2 2 NMOS
M6 8 2 2 2 NMOS
M7 3 3 2 2 NMOS
M8 6 3 8 8 NMOS
M9 5 5 6 6 PMOS
M10 5 5 5 5 PMOS

Iss 4 2 DC

VDD 5 0 DC
Vb1 2 0 DC
Vb2 3 0 DC
Vb3 5 0 DC
Vb4 7 0 DC
Vin 4 0 DC

* Ground node is considered as 0 in SPICE
