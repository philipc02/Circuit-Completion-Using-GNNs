spice
* SPICE Netlist

VBB 1 0 DC 1V
RB 1 2 10k
Q1 2 3 0 NPN
RC 3 4 3k
VCC 4 0 DC 9V

* End of netlist
