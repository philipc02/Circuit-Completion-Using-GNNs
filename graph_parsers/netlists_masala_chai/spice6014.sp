spice
* SPICE Netlist for the given schematic

V1 1 3 DC 0.5
V2 4 0 DC 0
V3 5 0 DC 5

R1 5 0 1k
R2 3 3 1k
R3 4 4 1k

Q1 5 3 3 PNP
Q2 5 4 2 NPN

.END
