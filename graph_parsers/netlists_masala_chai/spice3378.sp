plaintext
* NPN Transistor Circuit

V1 3 0 DC -5
R1 3 4 2k
Q1 4 2 0 NPN

* Connections:
* Node 3 is connected to the negative voltage source and resistor R1
* Node 4 is connected to the base of the NPN transistor
* Node 2 is connected to the collector of the NPN transistor
* Ground is connected to the emitter of the NPN transistor

.model NPN NPN
.end
