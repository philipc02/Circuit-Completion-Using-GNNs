spice
* SPICE netlist for the provided circuit

V1 4 2 DC 0
I1 7 3 DC 0
D1 3 1 D
VB 6 2 DC 1

* Define model for diode if needed
.model D D

.end
