plaintext
* NPN Transistor Circuit

Q1 2 5 3 NPN

RB 6 5 470k
RC 8 2 2k

VBB 5 4 DC 15
VCC 8 7 DC 15

* Node 3 and Node 7 connected to ground
3 0
4 0
7 0

.model NPN NPN
.end
