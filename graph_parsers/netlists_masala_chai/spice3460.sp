plaintext
* Transistors
Q1 2 6 3 NPN
Q2 2 4 3 NPN

* Current Source
I1 3 0 IBIAS

* Voltage Sources
V1 6 0 VJJ
V2 4 0 VJ2
V3 5 0 VDD
V4 0 3 VSS

* Resistors
RS1 6 3 RS
RS2 4 3 RS
RL1 2 6 RL
RL2 2 4 RL
R5_1 4 3 R5
R5_2 6 3 R5

.END
