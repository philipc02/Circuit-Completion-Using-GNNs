spice
* SPICE Netlist
* Voltage Source
Vsig 6 8 DC 0

* Resistors
Rsig 8 1 1k
RG1 4 0 1k
RG2 4 0 1k
Rs 5 7 1k
RD 2 3 1k
RL 3 22 1k

* Capacitors
C1 1 4 1u
C2 2 0 1u
C5 5 0 1u

* Dependent Current Source
Gm 2 5 4 0 1m

* End of Netlist
