spice
* RC Circuit Netlist
V1 6 7 AC 50 SIN(0 50 100)
R1 6 5 100k
C1 5 2 0.01u
C2 2 4 0.022u
R2 4 3 47k
.ends
