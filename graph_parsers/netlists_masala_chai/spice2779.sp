* Voltage sources
VDD 4 0 DC VDD
Vin1 1 0 DC Vin1
Vin2 3 0 DC Vin2
Vb 6 0 DC Vb

* Resistors
RD1 4 2 RD
RD2 2 2 RD

* Transistors
M1 4 1 5 5 NMOS
M2 2 3 5 5 NMOS
M3 5 6 5 5 NMOS

* End of netlist
