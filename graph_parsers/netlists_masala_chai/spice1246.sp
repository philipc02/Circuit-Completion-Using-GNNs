plaintext
* Transistors
M1 5 4 1 1 NMOS
M2 3 5 0 0 PMOS
M3 2 5 2 2 NMOS

* Current Source
I1 5 1 DC Rout

* Voltage Source
V1 3 0 DC VDD

* Voltage Inputs
Vin 4 0 DC Vin0
Vb 5 0 DC Vb
