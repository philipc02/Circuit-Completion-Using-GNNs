spice
* Components Identification
* Transistors
Q1 4 3 2 NPN

* Resistors
RC 4 5 1k
RE 2 3 1k

* Voltage Sources
VCC 5 0 DC 10V
VBB 3 0 DC 5V

* End of netlist
