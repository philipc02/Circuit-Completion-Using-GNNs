plaintext
* NMOS Transistor
M1 VDD 3 Vx Vx NMOS_MODEL

* Voltage Source
V1 3 0 DC 1V

* Capacitor
C1 Vx 0 1uF
