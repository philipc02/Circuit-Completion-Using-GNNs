spice
* SPICE Netlist for the given schematic

* NMOS Transistors
Msn 3 11 1 1 NMOS
M2 4 5 6 6 NMOS
M6 7 4 2 2 NMOS

* Capacitors
Cs 1 0 1uF
Cf 3 2 1uF
CL 4 0 1uF

* Resistors
RL 7 3 1k
Rtau 8 9 1k

* Voltage Sources
Vin_C 5 0 DC 0
Vout 8 0 DC 0

* End of Netlist
