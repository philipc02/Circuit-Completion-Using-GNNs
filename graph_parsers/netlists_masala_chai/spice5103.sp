spice
* SPICE Netlist
Iin 2 0 AC 1.5m
R1 3 4 1
R2 9 3 1k
RL 3 3 1
VCC 9 0 DC 15
VEE 3 0 DC -15
E1 3 5 9 0 1
