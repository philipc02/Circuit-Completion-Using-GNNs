* SPICE Netlist
* Components
Q1 2 1 5 NPN
Q2 4 2 5 NPN
IREF 6 0 DC
R1 6 1 0.0

* Nodes
* 1 - Base of Q1
* 2 - Collector of Q1 and Base of Q2
* 3 - Emitter of Q1 and Q2
* 4 - Collector of Q2
* 5 - Emitter of Q1 and Q2 connected to V-
* 6 - IREF source connected to V+
