plaintext
* Netlist for given schematic
VCC 5 0 DC 5V
VIN 4 0 DC 3.6V
VREF 3 0 DC 4V

R1 5 2 210
R2 5 3 235
R3 6 0 1k

I1 0 5 DC 3.4mA
I2 6 0 DC 3.4mA

Q1 2 4 6 NPN
Q2 2 3 6 PNPN

.END
