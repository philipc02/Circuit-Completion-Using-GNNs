* Transistor
Q1 2 5 4 QNPN

* Resistors
RB1 1 3 1k
RB2 5 3 1k
RC 1 2 1k

* Voltage Source
VCC 1 0 DC 12V

.model QNPN NPN
.end
