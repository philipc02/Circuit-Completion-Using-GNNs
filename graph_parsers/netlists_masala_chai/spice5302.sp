spice
* SPICE Netlist
V1 6 9 DC 10

R1 4 7 33k
R2 8 3 33k
R3 5 2 33k

* Ground connections
V0 9 0 DC 0
V0 7 0 DC 0
V0 3 0 DC 0
V0 2 0 DC 0

.END
