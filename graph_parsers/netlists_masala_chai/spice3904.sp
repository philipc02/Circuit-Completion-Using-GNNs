plaintext
* BJT Amplifier Circuit

VCC 8 7 DC 2.5V
R1 5 2 1k
R2 2 7 1k
RC 8 4 6k
RE 3 7 2k

* NPN BJT
Q1 4 2 3 NPN

* End of netlist
