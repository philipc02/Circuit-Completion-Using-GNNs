* Transistors
M1 3 4 3 3 PMOS
M2 3 3 3 3 PMOS
M3 5 5 3 3 PMOS
M4 3 3 3 3 PMOS

M5 2 4 2 2 NMOS
M6 2 3 2 2 NMOS
M7 2 5 2 2 NMOS
M8 2 2 2 2 NMOS

* Capacitors
C1 4 0 4n
C2 3 0 4n
C3 2 0 4n
C4 2 0 4n

* Voltage Source
VDD 3 0 DC 5V

* End of Netlist
