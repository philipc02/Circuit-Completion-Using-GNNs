plaintext
* NMOS Transistors
M1 7 A 0 0 NMOS
M2 4 nA 0 0 NMOS

* PMOS Transistors
M3 2 3 2 2 PMOS
M4 2 3 2 2 PMOS

* Resistors
R1 Y 5 R1_VALUE
R2 5 0 R2_VALUE

* Voltage Source
VDD 2 0 VDD_VALUE

* Notes:
* 1. Replace R1_VALUE, R2_VALUE, and VDD_VALUE with actual values.
* 2. Node numbers are based on annotated image.
