spice
* SPICE Netlist for the circuit

* Current Source
Is 2 3 DC 0

* Resistors
R1 2 3 R1_value
Rz 22 2 Rz_value
R2 5 6 R2_value

* Capacitors
C1 2 4 C1_value
C 22 4 C_value
C2 4 6 C2_value

* Voltage-Controlled Current Source
Gm 4 6 4 5 gm_value

* Note: Replace R1_value, Rz_value, R2_value, C1_value, C_value, C2_value, and gm_value with actual values.
