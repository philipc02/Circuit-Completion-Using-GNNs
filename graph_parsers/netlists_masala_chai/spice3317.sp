* NMOS Transistors
M1 5 6 8 8 NMOS
M2 2 2 7 7 NMOS

* PMOS Transistors
M3 3 5 3 3 PMOS
M4 4 2 4 4 PMOS

* Current Source
I1 8 0 DC Iss

* Voltage Supply
VDD 3 0 DC VDD

* Input Voltage
Vin 6 0 DC Vin

.end
