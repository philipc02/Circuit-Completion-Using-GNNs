plaintext
* SPICE Netlist for the Circuit

V1 3 4 DC <voltage_value>
* Voltage source V1 connected between nodes 3 and 4.

* Op-amp model
* Connecting nodes as per the annotated schematic: non-inverting input(3), inverting input(2), and output(5)
XOPAMP 2 3 5 OPAMP_MACRO
* Assumes OPAMP_MACRO is a predefined op-amp model in the library.

* Ground connection
VSS 4 0 DC 0
* Ground reference
