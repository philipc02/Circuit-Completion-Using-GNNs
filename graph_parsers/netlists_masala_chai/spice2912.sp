spice
VDD 1 0 DC 5V
RD 1 2 1k
M1 2 Vin 0 NMOS
CL 2 0 10p
Vin Vin 0 DC 0V
