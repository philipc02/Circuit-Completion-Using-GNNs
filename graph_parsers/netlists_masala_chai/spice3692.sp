plaintext
* SPICE Netlist
M1 4 2 6 6 NMOS
R1 5 3 R
D1 3 4 LED
V1 2 0 DC Vi
V2 5 0 DC 5V
