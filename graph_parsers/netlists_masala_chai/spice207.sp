spice
* Transistors
M1 2 3 4 4 NMOS
M2 2 3 5 5 NMOS
M11 5 2 6 6 PMOS
M12 6 2 5 5 PMOS

* Voltage Sources
Vi 3 0 DC 0
VOS1 4 0 DC 0
VOS2 4 0 DC 0
VDD 5 0 DC VDD_value
VSS 5 0 DC VSS_value

* Resistor
RL 6 5 RL_value

* End of Netlist
