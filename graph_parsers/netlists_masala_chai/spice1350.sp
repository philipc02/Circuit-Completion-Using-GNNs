* MOSFET Transistor
M1  3 2 0 0 NMOS

* Current Source
I1  0 2 DC 1

* Resistors
Rout 3 1 ROUT
r_pi1 2 0 rpi1

* Simulation Control
.end
