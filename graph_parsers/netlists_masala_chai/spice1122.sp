spice
* NMOS Transistors
M1 2 Vin 2 2 NMOS
M2 2 2 4 4 NMOS

* Resistor
RD 3 2 1k

* Voltage Source
VDD 3 0 DC 5V

* End of Netlist
