spice
Cgd 2 2 Cgd_value
Cgs 2 4 Cgs_value
Csb 4 5 Csb_value
Cdb 2 5 Cdb_value

G1 4 2 2 4 gm_value
G2 4 6 5 4 gmb_value

Rro 3 2 Ro_value
