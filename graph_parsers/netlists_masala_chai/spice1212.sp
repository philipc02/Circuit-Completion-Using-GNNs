* NMOS Amplifier Circuit
VDD 2 0 DC 1.8
R1 2 3 500
R2 3 1 <Value_Unknown>
RS 4 1 100
M1 2 4 1 1 NMOS
* Assume NMOS model is defined elsewhere

* End of netlist
