spice
* NMOS Transistor (M1)
M1 3 2 2 2 NMOS

* Resistor (RD)
R1 3 3 RD

* Voltage Source (VDD)
VDD 3 0 DC VDD_value

* Input
Vin 2 0 DC Vin_value

* Analysis Control
.TRAN 1n 10u
.END
