spice
* NPN BJT Amplifier Circuit

* NPN BJT
Q1 2 3 4 NPN

* Resistors
R1 3 0 R_G_parallel_R1_parallel_R2
R2 4 0 R_E

* Node Connections:
* 1 - Collector
* 2 - Base
* 3 - Emitter
* NPN: (Collector, Base, Emitter)

.END
