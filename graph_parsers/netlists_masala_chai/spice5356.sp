plaintext
* SPICE Netlist for Simple Resistor Circuit

V1 3 0 DC 1.5

R1 3 2 100k
R2 2 4 56k
RL 2 0 RL_value

* The net A corresponds to node 2
* The net B corresponds to node 4

.END
