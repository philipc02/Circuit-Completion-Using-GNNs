spice
* Differential Amplifier

M1 5 3 0 0 NMOS
M2 6 3 0 0 NMOS
M3 2 5 0 0 PMOS
M4 2 6 0 0 PMOS

I1 5 6 DC i0

V1 3 0 DC (vid/2)
V2 4 0 DC -(vid/2)
