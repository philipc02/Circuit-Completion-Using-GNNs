spice
* Transistors
M1 4 6 7 7 NMOS
M2 3 4 7 7 NMOS
M3 2 4 5 5 PMOS
M4 3 3 5 5 PMOS
M5 2 21 2 2 PMOS
M6 3 23 13 13 PMOS
M7 2 2 2 2 PMOS
M8 2 23 2 2 PMOS
M9 3 24 13 13 PMOS
M10 2 21 2 2 PMOS

* Capacitors
CC 4 5  Cc_value
CCc 2 5  CCc_value
CCc 3 13 CCc_value

* Load capacitors
CL 4 0 CL_value
CL 3 0 CL_value

* Voltage Sources
VDD 2 0 DC VDD_value
Vin 6 0 DC Vin_value
Vout1 4 0
Vout2 3 0

* Current Source
Iss 7 0 DC Iss_value

.end
