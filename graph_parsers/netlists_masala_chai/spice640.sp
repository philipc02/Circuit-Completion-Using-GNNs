* Diodes
D3 N1 N2 Dmodel
D4 N1 0 Dmodel

* Resistor
RL N2 0 1k

* Voltage Sources
Vin N1 0 DC 5V
Vout N2 0

.model Dmodel D
