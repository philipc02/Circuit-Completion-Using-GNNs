spice
* SPICE netlist for the given schematic

V1 3 0 DC 5V

R1 6 7 10k
R2 6 3 10k
R3 3 2 20k
R4 2 4 10k
R5 4 4 30k

Q3 3 6 2 NPN
Q4 2 3 4 NPN

.END
