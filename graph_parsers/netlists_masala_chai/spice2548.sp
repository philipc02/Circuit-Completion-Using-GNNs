spice
* SPICE Netlist for the Circuit

M1 2 6 5 5 NMOS
M2 2 4 VDD VDD PMOS
Vx 2 5 DC <value_of_Vx>
Ix 2 3 DC <value_of_Ix>

*.model NMOS NMOS parameters...
*.model PMOS PMOS parameters...
