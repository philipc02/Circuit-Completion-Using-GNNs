spice
* SPICE netlist for given schematic
L1 4 5 100m
L2 2 7 50m
L3 3 6 50m
