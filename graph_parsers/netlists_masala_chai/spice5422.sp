plaintext
* SPICE netlist for the given circuit
VS 6 8 AC 10 SIN(0 10 2MEG)
R1 6 2 330
L1 2 4 50u
R2 7 5 1k
L2 5 3 100u
C1 8 0 0.1u
.ends
