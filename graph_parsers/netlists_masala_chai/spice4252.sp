spice
* SPICE Netlist

Q0 4 1 5 PNP
Q1 6 4 8 NPN
Q2 6 4 7 PNP

CC 3 4 1u

RL 5 4 10k
R1 4 8 15k

Vcc 7 0 DC 12V
Vi 1 0 DC 0V

* End of Netlist
