* Netlist for the given schematic

Vp 3 0 DC Vp
L1 3 0
C1 2 0
D1 3 2 D_model

.model D_model D
