spice
* SPICE Netlist

* Current Source
IREF 3 2 DC 0

* Transistors
QREF 2 2 4 QMOD
Q1 2 2 3 QMOD
Q2 2 2 5 QMOD

* Model for NPN Transistor
.model QMOD NPN
