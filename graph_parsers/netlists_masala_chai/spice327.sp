spice
* SPICE Netlist

Q1 8 2 5 NPN
Q2 5 3 4 NPN
Q3 3 6 3 NPN

I1 2 0 DC
R1 6 0 30k

VSUPPLY 8 0 DC

VOUT 7 0 DC

* End of Netlist
