plaintext
* SPICE Netlist for NPN Transistor Circuit

V1 5 0 DC 3V
R1 4 5 1k
R2 2 0 1k
Q1 4 3 2 NPN

*.END
