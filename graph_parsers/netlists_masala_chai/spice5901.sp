plaintext
* SPICE Netlist for the Schematic

* PMOS Q6
M1 3 2 5 5 PMOS

* NMOS Q2
M2 5 0 4 4 NMOS

* Current Source I2
I2 5 5 DC 0

* Voltage Sources
VDD 3 0 DC VDD
VSS 0 4 DC VSS

* Input Voltage
VI 2 0 DC VI_value

* End of Netlist
