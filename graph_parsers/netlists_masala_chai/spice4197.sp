spice
* Op-Amp Circuit

R1 3 2 500k
R2 2 4 1k
XOP 3 2 4 3 OPAMP

* OPAMP Model
.SUBCKT OPAMP 1 2 3 4
* (no specific model details as this is symbolic)
.ENDS

.END
