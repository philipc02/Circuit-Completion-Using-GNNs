spice
* NPN Transistor Circuit
VCC 3 0 DC VCC
RB 3 2 RB
RC 3 5 RC
Q1 5 2 6 NPN
* Node 6 is connected to the ground
