plaintext
* NMOS M1
M1 N001 Vin N003 N003 NMOS

* PMOS M2
M2 Vout N002 VDD VDD PMOS

* Resistor RS
RS Vin N001 1k

* Resistor R1
R1 N003 0 1k

* Voltage Sources
VDD VDD 0 DC 5V
Vb N002 0 DC 0.7V
