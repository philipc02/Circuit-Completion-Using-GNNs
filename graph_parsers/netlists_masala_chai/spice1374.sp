plaintext
*SPICE Netlist
Q1 5 vin 0 NPN
Q2 2 5 3 NPN
R1 3 1 rOS
V1 1 0 VCC
