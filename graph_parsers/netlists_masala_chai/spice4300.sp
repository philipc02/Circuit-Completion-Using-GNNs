spice
* Transistors
Q1 3 5 4 QNPN
Q2 3 2 4 QNPN

* Resistors
RC1 3 6 RC
RC2 3 6 RC

* Current Source
I_Q 4 2 DC I_Q

* Voltage Source
V_cm 5 0 DC V_cm

* Model Definitions
.model QNPN NPN
