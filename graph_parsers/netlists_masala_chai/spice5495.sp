spice
* SPICE Netlist

VCC 6 0 DC [VCC]
Vin 9 0 AC [Vin]

R1 6 3 [R1]
R2 3 8 [R2]
R3 6 2 [R3]
R4 3 5 [R4]

C1 3 9 [C1]
C2 5 4 [C2]
C3 2 4 [C3]

Q1 2 3 5 NPN

.END
