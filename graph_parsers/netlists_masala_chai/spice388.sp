spice
* SPICE Netlist
VDD 4 0 DC 15V
RC 4 2 10k
RF 5 2 20k
IIN 5 0 DC 1mA
Q1 3 2 5 NPN

*.model NPN NPN
.end
