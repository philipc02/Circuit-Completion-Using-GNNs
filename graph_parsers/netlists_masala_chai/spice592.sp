spice
V1 2 4 Vx
I1 2 2 Ix
R1 2 3 1k
D1 2 3 D_model
