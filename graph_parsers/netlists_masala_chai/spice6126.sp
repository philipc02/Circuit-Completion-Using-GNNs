spice
* NMOS Transistor
M1 5 4 2 2 NMOS

* PMOS Transistor (Q2 has a different orientation)
M2 3 2 0 0 PMOS

* Current Sources
I1 2 0 DC <VALUE_I1>
I2 6 3 DC <VALUE_I2>

* Node 6 is connected to V_DD
VDD 6 0 DC <VALUE_VDD>
