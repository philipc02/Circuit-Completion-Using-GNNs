plaintext
* SPICE Netlist
M1 3 2 0 0 NMOS
I1 6 3 DC 1mA
C1 1 2 1uF
C2 2 3 1uF
VDD 6 0 DC 5V
Vin 1 0 DC 0V
Vout 4 0
