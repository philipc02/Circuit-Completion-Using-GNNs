spice
* Op-Amp Non-Inverting Amplifier

* Voltage Source
V1 1 2 AC 1 SIN(0 1m 1k)

* Op-Amp
XU1 1 3 4 5 6 OPAMP

* Feedback Resistor
Rf 4 3 7.5k

* Input Resistor
R1 3 2 100

* Power Supplies
VCC 5 0 DC 9
VEE 6 0 DC -9

* End of Netlist
