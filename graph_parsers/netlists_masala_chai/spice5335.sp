spice
* SPICE Netlist
Vs 2 7 DC 24V
R1 2 4 12k
R2plusB 4 6 12k
RL1 4 3 100k
* Ground connections
Vgnd 6 0 0V
Vgnd 3 0 0V
Vgnd 7 0 0V
.end
