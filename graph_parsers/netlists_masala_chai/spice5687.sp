* NMOS Transistor
M1 4 5 2 2 NMOS

* Current Source
I1 3 4 DC 1A

* Voltage Source
V1 3 2 DC 1V

* Note: Node numbers are assigned based on the red-highlighted nets.
