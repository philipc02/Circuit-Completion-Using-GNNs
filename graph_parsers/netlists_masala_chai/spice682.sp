plaintext
Iin 2 3 DC 0.5A
D1 2 3 D_model
R1 2 3 1k
Vb 2 3 DC 5V

.model D_model D
