spice
* Transistors
Q1 3 2 5 NPN
Q2 4 3 6 NPN

* Resistors
RC1 2 VCC 22
RC2 4 VCC 22
RS1 7 2 1k
RS2 8 4 1k

* Capacitors
CCS1 2 22 1u
CCS2 4 22 1u
Cµ1 3 4 1u
Cµ2 3 6 1u
Cπ1 3 5 1u
Cπ2 3 7 1u

* Voltage Source
VCC VCC 0 DC 10

* Current Source
IEE 5 0 1mA

* Input Voltages
Vin1 7 0 0V
Vin2 8 0 0V

* Outputs and connections
* All connections according to annotated nets

.END
