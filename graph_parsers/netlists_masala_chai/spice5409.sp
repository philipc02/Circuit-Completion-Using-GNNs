spice
* SPICE Netlist for the given circuit

Vs 5 3 AC 1 SIN(0 1 1k)
R1 4 3 2.2k
R2 4 2 1.0k
C1 3 3 0.047u
C2 2 3 xxx  ; C2 value is not given

.end
