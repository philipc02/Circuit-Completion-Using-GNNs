M1 3 Vb1 X NMOS
   M2 X Vb2 0 NMOS
   Rout 3 0 R
   Vb1 Vb1 0 DC
   Vb2 Vb2 0 DC
