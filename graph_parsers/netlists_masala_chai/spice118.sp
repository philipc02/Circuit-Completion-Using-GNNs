spice
* Netlist for the given schematic
.SUBCKT CIRCUIT 1 6
M1 5 4 3 3 NMOS
M2 4 5 3 3 NMOS
M3 3 4 6 6 PMOS
M4 4 3 2 2 PMOS
IIN 2 0 DC <current_value>
.ENDS CIRCUIT
