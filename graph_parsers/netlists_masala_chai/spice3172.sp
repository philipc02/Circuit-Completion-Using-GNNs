plaintext
* SPICE Netlist

VDD 2 0 DC VDD

I1 9 2 DC I
I2 28 2 DC I

R1 2 3 R

Q1 9 5 4 NPN
Q2 2 3 4 NPN

* Ground
VBE2 4 0 DC 0

* End of Netlist
