spice
* PMOS Transistor (Drain, Gate, Source)
M1 2 G2 V+ V+ PMOS

* NMOS Transistor (Drain, Gate, Source)
M2 3 G1 0 0 NMOS

* Voltage Source V+
V1 V+ 0 DC VDD

* Output
R1 3 Output 0
