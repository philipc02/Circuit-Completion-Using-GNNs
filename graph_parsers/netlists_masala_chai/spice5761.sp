spice
* Transistor
Q1 3 2 4 NPN

* Resistors
R1 2 3 27k
R2 4 0 750

* Voltage Sources
V1 5 3 DC 5V
V2 2 0 DC 4.3V
V3 4 0 DC 3.0V

* Ground
.GROUND 0

.END
