spice
* NMOS transistor M1
M1 2 1 3 3 NMOS

* Voltage Source
V1 3 0 1V

* Model definitions
.model NMOS NMOS level=1
