* SPICE Netlist for the Resistor Network

* Voltage Source
V1 6 7 DC Vs

* Resistors
R1 7 3 R1
R2 3 4 R2
R3 5 4 R3
R4 4 2 R4
R5 4 2 R5

* End of Netlist
