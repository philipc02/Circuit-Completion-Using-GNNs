V1 4 0 DC 0
   R1 4 2 75
   RC 5 2 12k
   RL 2 0 12k
   C1 2 3 INF
   C2 2 0 INF
   I1 3 0 DC 0.33m
   Q1 5 2 3 NPN
