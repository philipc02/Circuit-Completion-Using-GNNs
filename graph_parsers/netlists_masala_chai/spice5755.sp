spice
* SPICE Netlist

V1 3 0 DC 10V
I1 4 55 DC 50uA
Q1 3 2 4 QNPN

.model QNPN NPN
