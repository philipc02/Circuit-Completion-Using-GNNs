plaintext
* SPICE Netlist
G1 2 5 1 0 Gm
R1 4 3 Zo
V2 3 5 0
I2 4 2 DC 0
