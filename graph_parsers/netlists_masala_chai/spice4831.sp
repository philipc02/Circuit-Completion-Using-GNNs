spice
* Netlist for the given circuit schematic
I1 2 3 DC <value>
RE 3 0 <value>
RC 4 2 <value>

**.end**
