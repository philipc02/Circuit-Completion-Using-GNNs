spice
* SPICE Netlist for the given circuit
* Components
VCC 6 0 DC VCC

R1 5 4 R1
R2 4 0 R2
R3 6 2 R3
R4 2 0 R4

* Output
Vout 2 4 DC

* End of Netlist
