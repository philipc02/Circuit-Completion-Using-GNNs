spice
* Op-amp circuit
* Connections are based on the nodes marked in the annotated image.

* Voltage Input Source
VI 1 0 DC 0

* Op-Amp
XU1 1 2 2 2 2 OPAMP

* Resistor RL
RL 2 3 1000

* Resistor R1
R1 3 5 1000

* Ground
VSS 5 0 DC 0

.end
