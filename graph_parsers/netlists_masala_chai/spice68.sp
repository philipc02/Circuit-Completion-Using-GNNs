* SPICE Netlist

* Transistors
Q1 3 6 4 NPN
Q2 2 4 5 NPN

* Current Source
I1 4 0 DC IBIAS

* Voltage Supply
VCC 3 0 DC VCC

* End of Netlist
