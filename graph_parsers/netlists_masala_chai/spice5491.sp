spice
* Transistor
Q1 3 8 7 NPN

* Resistors
R1 1 3 <value_R1>
R2 8 9 <value_R2>
R3 5 2 <value_R3>
R4 9 6 <value_R4>
R5 10 6 <value_R5>
RC 3 4 <value_RC>
RE 7 2 <value_RE>

* Capacitors
C1 5 2 <value_C1>
C2 8 2 <value_C2>
C3 12 6 <value_C3>
C4 4 2 <value_C4>
CE 7 2 <value_CE>

* Voltage Source
VCC 1 2 <value_VCC>

* .end
