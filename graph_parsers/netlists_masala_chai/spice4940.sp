spice
* NMOS Amplifier SPICE Netlist

M1 5 4 3 3 NMOS
VDD 1 2 DC VDD
VSS 3 0 DC VSS
RD 2 5 RD
RG 4 6 RG
RS 5 3 RS

* NMOS model
.model NMOS NMOS

.end
