spice
*MOSFET SPICE Netlist

*M1 MOSFET: Vout, A, 2 (GND)
M1 Vout A 2 NMOS

*M2 MOSFET: 2 (GND), B, 2 (GND)
M2 2 B 2 NMOS

*M3 MOSFET: C, 2, 2 (GND)
M3 C 2 2 NMOS

*.end
