plaintext
* Netlist for the given circuit

V1 8 5 DC 2V
V2 3 4 DC 3V

R1 8 5 1k
R2 5 3 2.2k
R3 5 6 1k
R4 7 3 1k
R5 6 3 2.2k

.END
