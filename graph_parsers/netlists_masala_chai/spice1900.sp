plaintext
V0 3 4 DC [Value]  ; Replace [Value] with the actual voltage value.
C1 3 2 [C1_Value]  ; Replace [C1_Value] with the actual capacitance.
L1 2 3 [L1_Value]  ; Replace [L1_Value] with the actual inductance.
Rp 2 3 [Rp_Value]  ; Replace [Rp_Value] with the actual resistance.
