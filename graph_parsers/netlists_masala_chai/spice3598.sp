spice
* SPICE Netlist

V1 2 5 DC
R1 2 3 1k
D1 2 2 DMOD
D2 2 2 DMOD
D3 4 3 DMOD
.model DMOD D
