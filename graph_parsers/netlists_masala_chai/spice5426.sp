spice
* Netlist for the given circuit

* Voltage Source
V1 9 8 AC 18 SIN(0 18 80k)

* Resistors
R1 9 10 1.2k
R2 10 4 3.3k
R3 3 5 5.6k

* Inductors
L1 9 3 10m
L2 2 5 8m

* Ground
V1 8 0 0
