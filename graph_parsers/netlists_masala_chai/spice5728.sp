plaintext
* SPICE Netlist
M1 3 2 3 3 NMOS
R1 3 2 400k
V1 4 3 DC 5V
V2 3 0 DC -5V
