plaintext
* SPICE Netlist for BJT Circuit
VBB 1 0 DC VBB
VCC 3 0 DC VCC
RB 5 1 RB
RC 2 3 RC
Q1 2 5 4 QNPN
.model QNPN NPN
