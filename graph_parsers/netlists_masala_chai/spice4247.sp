plaintext
*MOSFETS
M1 4 3 4 4 NMOS
M2 2 5 6 6 NMOS
M3 3 3 4 3 PMOS

*CURRENT SOURCE
I_REF 4 6 DC <value>

*VOLTAGE SOURCES
VPLUS 3 0 DC 5
VMINUS 6 0 DC -5

*OUTPUT CURRENT
IO 2 0 <value>
