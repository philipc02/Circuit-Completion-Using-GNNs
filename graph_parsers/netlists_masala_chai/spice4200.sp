spice
* SPICE Netlist

V1 2 4 DC Vin
R1 2 4 R
R2 2 2 2R
R3 5 3 2R
R4 5 4 R
X1 2 2 3 OPAMP

* Control statements
.OP
.END
