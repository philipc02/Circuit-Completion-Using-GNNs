* Transistor Q1
Q1 5 5 8 NPN

* Transistor Q2
Q2 5 5 5 NPN

* Transistor Q3
Q3 6 5 8 PNP

* Transistor Q4
Q4 3 5 8 PNP

* Transistor Q5
Q5 5 5 3 NPN

* Transistor Q6
Q6 4 2 0 NPN

* Transistor Q7
Q7 4 7 2 PNP

* Current Source I1
I1 8 5 DC 0.1mA

* Current Source I2
I2 2 4 DC 1mA

* Capacitor C
C1 5 3 C

* Resistor RL
RL 2 0 RL

* Voltage Source +10V
V1 2 0 DC 10V

* Voltage Source -10V
V2 3 0 DC 10V

.end
