spice
* NMOS Amplifier Circuit
M1 3 4 3 3 NMOS L=1u W=1u
VDD 4 0 DC 12V
VIN 1 3 AC 100mV
RD 4 5 470
RL 5 2 2k
RG 1 3 1MEG
C1 1 3 10n
C2 5 2 10n
.model NMOS NMOS
.end
