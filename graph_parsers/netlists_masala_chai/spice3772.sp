spice
* SPICE Netlist

Vi 6 3 DC 'V'
Gm 3 4 2 6 'gm'
Ro1 4 5 'ro1'
Ro2 3 5 'ro2'
