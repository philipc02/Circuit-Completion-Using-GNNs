plaintext
* NMOS Amplifier Circuit

MN1 drain gate source 0 NMOS
RD drain VDD 1000

VDD VDD 0 DC 5
Vi gate 0 DC 1

.model NMOS NMOS
