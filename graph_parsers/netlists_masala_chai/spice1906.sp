plaintext
* NMOS Differential Pair with Current Source

M1 3 Vin1 2 2 NMOS
M2 4 Vin2 2 2 NMOS
I1 2 0 DC Iss

* Voltage and Current sources
Vin1 Vin1 0 DC
Vin2 Vin2 0 DC
