spice
* Resistor Bridge Network
* Nodes: 6 (V+), 7, 2 (Ground), 5, 4, 3 (Vo1+ and Vo1-)

* Voltage Source
V1 6 2 DC V+

* Resistors
R1 6 7 R+DeltaR
R2 7 2 R-DeltaR
R3 2 5 R-DeltaR
R4 5 4 R+DeltaR

* Voltage measurement across Vo1
* Vo1+ connected to node 7, Vo1- connected to node 5

* End of Netlist
