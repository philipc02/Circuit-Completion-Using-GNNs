spice
* SPICE Netlist for the given schematic

* Capacitors
Cgd 3 8 Cgd
Cgs 3 4 Cgs

* Controlled Current Source
Gm 4 8 CUR 3 4 gm

* Resistors
Ro 8 5 ro
Rgm 3 4 RGm

* Nodes
* 2 = D
* 3 = G
* 4 = S
* 5 = Additional node from Ro
