spice
* SPICE Netlist for the Circuit
IX 5 2 DC 1A
R1 4 2 2k
D1 4 3 D
D2 3 2 D
