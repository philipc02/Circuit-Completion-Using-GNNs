spice
* NMOS Amplifier Circuit
M1 3 2 0 0 NMOS
R1 5 2 R1_value
R2 2 0 R2_value
RD 4 3 RD_value
VDD 4 0 VDD_value

.model NMOS NMOS
