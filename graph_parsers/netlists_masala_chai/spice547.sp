plaintext
*MOSFET Differential Pair Circuit

* NMOS Transistors
M1 2 6 8 8 NMOS
M2 2 6 8 8 NMOS

* PMOS Transistors
M21 4 5 2 2 PMOS
M22 3 2 2 2 PMOS

* Voltage Sources
V1 5 0 Vdd/2
V2 6 0 Vdd/2

* End of Netlist
