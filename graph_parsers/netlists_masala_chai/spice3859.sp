plaintext
* NPN BJT Amplifier Circuit

V1 1 0 DC 5V
RB 5 4 150k
RC 2 3 5k
Q1 3 4 6 NPN
V2 1 5 DC 0V

* Nodes
* 1: V+
* 2: Collector
* 3: Output (vO)
* 4: Base
* 5: Input (vI)
* 6: Ground

.END
