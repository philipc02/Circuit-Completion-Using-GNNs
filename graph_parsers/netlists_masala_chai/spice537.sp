plaintext
* SPICE Netlist
* PMOS and NMOS transistors
M5h 3 5 4 4 PMOS
M2 0 2 3 3 NMOS
M6 0 6 3 3 NMOS

* Capacitors
C_f 3 4 1pF
C_s 3 0 1pF
C_ich 6 0 1pF
C_L 3 4 1pF

* Voltage Sources
Vin 1 0 DC 1V
Voc 2 0 DC 1V

* End of Netlist
