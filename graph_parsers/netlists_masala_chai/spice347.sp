spice
I1 2 6 DC 0 ; Current source Ii
RF 4 3 1k   ; Feedback resistor (assumed value)
V1 3 0 DC 0 ; Output voltage Vo

* Op-Amp connections
* Assumed ideal op-amp with input at node 2 and output at node 3
* Reference node (ground) is node 6

.END
