spice
* SPICE Netlist

V1 8 0 V+DC
V2 9 0 V-DC

Q13A 2 8 3 QMOD_N
Q14 3 3 4 QMOD_P
Q15 3 4 4 QMOD_P
Q18 2 8 3 QMOD_N
Q19 4 2 9 QMOD_N
Q20 4 6 4 QMOD_N
Q21 7 5 4 QMOD_N
Q22 4 6 9 QMOD_N
Q24 6 9 9 QMOD_N

R6 3 4 27
R7 4 7 22
R10 9 2 50000
R11 9 6 50000
RL 7 0 RL_VALUE

.model QMOD_N npn
.model QMOD_P pnp
