plaintext
* NMOS Transistors
M1 N002 2 2 2 NMOS
M3 N002 N002 3 3 NMOS

* Voltage Sources
Vin1 2 0 DC 0V

* Output Node
Vout1 N002 0
