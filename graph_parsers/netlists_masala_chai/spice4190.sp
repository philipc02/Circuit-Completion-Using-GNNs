plaintext
* Op-Amp Amplifier Circuit
* Resistors
R1 1 3 20k
R2 3 4 200k
R3 3 5 20k

* Op-Amp
* Assuming ideal op-amp model
XOPAMP 2 3 4 OPAMP

* Voltage Input
Vin 1 0 DC V1

* Ground
* Node 2 and node 5 are connected to ground
V2 2 0 DC 0
V5 5 0 DC 0

* End of Netlist
