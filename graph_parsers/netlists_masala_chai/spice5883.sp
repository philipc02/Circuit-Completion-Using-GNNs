spice
* SPICE Netlist
M1 1 3 2 2 nmos
R1 1 2 10k
C1 3 0 1u
C2 1 20 1u
V1 3 0 DC vi
V2 20 0 DC vo1
