* SPICE Netlist
V1 1 2 DC v1
G1 2 4 1 2 gm
R0 4 2 R0
VX 4 3 DC vx
