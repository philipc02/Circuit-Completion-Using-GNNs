spice
* SPICE Netlist for the Circuit

* Voltage Source
Vt 13 10 DC ...

* Resistors
Rt 13 4 ...
Rg 5 6 ...
Rx 5 6 ...
Rc 2 3 ...
Ro 2 3 ...
Rl 3 9 ...

* Current Source
Iin 4 5 DC ...

* Voltage Controlled Current Source
Gm 6 2 VALUE={gm * V(5,6)}

* Output Voltage
Vout 3 12 DC ...

.end
