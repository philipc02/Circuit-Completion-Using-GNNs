spice
* SPICE Netlist

* Voltage Source
V1 7 1 DC

* Transconductance Amplifiers (as Controlled Current Sources)
Gm1 3 1 7 1 gm1
Gm2 4 1 3 1 gm2
Gm3 6 1 7 1 gm3

* Resistors
R1 3 2 R1
R2 4 2 R2

* Capacitors
C1 3 5 C1
C2 4 5 C2
Cm 3 4 Cm

* Output
Vo 5 2 DC
