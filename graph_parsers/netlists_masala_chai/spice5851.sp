spice
* SPICE Netlist
M1 3 7 2 2 NMOS
RD 6 3 RD_value
RS 2 4 RS_value
RG1 5 7 RG1_value
RG2 7 8 RG2_value
VDD 5 0 DC VDD_value
