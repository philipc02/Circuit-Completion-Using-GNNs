plaintext
* SPICE Netlist for NMOS Amplifier Circuit

VDD 5 0 DC 5V
Vin 1 0 DC 0V

RD 5 2 1k
R1 2 0 1k
R2 2 0 1k

M1 2 1 0 0 NMOS_MODEL

.model NMOS_MODEL NMOS
