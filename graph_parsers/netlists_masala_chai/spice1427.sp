* SPICE netlist for the given circuit

M1 4 5 2 2 NMOS
M2 2 2 2 2 NMOS
RD 3 4 1k
VDD 3 0 DC 5V

* End of netlist
