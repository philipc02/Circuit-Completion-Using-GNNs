* Diode-connected circuit

D1 vi 1 D
C1 1 2 {capacitor_value}
R1 2 0 6.8k

* Voltage definitions
* vi and vo are the input and output
* V_B is part of the capacitor annotation

.END
