plaintext
* SPICE Netlist

*Resistors
Rb 4 3 rb
Rs 3 0 rs
Rl 2 3 rL

*Current Sources
Ib 3 0 dc ib
Is 4 0 dc vs
I1 2 3 dc i1

*Voltage Source
V1 3 0 v1

*Capacitor
Cπ 3 2 cπ

.end
