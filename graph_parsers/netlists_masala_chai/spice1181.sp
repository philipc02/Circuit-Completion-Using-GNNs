spice
* SPICE netlist for the circuit

V1 3 6 DC 0
Gm 4 3 VALUE = {gm*V(3)}
R0 3 2 R=R0
Ix 5 5 DC 0

* End of netlist
