spice
* Transistor
Q1 5 6 3 NPN

* Voltage Source (AC)
Vg 7 0 AC 1

* Resistors
RG 7 6 RG_value
R1 5 6 R1_value
R2 6 0 R2_value
RC 5 2 RC_value
RE 3 0 RE_value
RL 2 0 RL_value

* Capacitors
Cin 7 6 Cin_value
Cout 5 2 Cout_value
CE 3 0 CE_value
