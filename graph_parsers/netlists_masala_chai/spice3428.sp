spice
M1 32 2 0 0 NMOS_MODEL
VGG 2 0 DC <VGG_VALUE>
VDD 32 0 DC <VDD_VALUE>
