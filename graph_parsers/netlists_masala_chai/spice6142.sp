plaintext
* Transistor Q1
M1 4 8 4 4 NMOS

* Transistor Q2
M2 9 2 4 4 NMOS

* Transistor Q3
M3 2 7 4 4 NMOS

* Current Source IBIAS
I1 2 3 DC

* Resistor RSIG
R1 7 4 RSIG

* Voltage Source VSIG
V1 7 7 DC VSIG

* Node 9 is the output (Vo)
