plaintext
* SPICE netlist for the given schematic
R1 v_I v_O 4k
D1 v_O V_B Dmodel
.model Dmodel D
