spice
* NMOS Amplifier Circuit
M1 Vout Vb Vin Vin NMOS_L W=10u L=1u
RD VDD Vout 1k
RS Vin Vin 500
VDD VDD 0 DC 5V
Vb Vb 0 DC 2.5V
Vin Vin 0 DC 0V
.model NMOS_L NMOS Level=1
.end
