plaintext
* SPICE Netlist for the given schematic

V1 6 2 DC 2.5

R1 6 3 100
R2 3 4 78
R3 2 4 47
R4 3 5 22
RL 5 4

.END
