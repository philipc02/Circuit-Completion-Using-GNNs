plaintext
* SPICE netlist for the schematic

* Resistors
R1 2 3 RD
R2 2 2 RD

* Transistors (PMOS)
M1 3 4 2 2 PMOS
M2 3 2 2 2 PMOS

* Capacitors
C1 3 3 CL
C2 2 3 CL

* Voltage Source
VDD 2 0 DC VDD

* Output
Vout 1 0

* End of netlist
