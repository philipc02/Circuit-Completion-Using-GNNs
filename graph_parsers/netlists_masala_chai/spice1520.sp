spice
* Differential Amplifier

VDD 4 0 DC VDD
VCM 6 0 DC VCM

M1 2 6 3 3 NMOS
M2 2 2 3 3 NMOS

RD1 5 2 RD
RD2 4 2 RD

ISS 3 0 DC ISS

* End of Netlist
