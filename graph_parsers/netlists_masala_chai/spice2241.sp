spice
* NMOS Transistor
M1 3 Vin 0 0 NMOS

* Resistor
RD 2 3 RD_VALUE

* Voltage Source for VDD
VDD 2 0 DC 1.8

* Input Voltage Source
Vin Vin 0 DC Vin_VALUE

.model NMOS NMOS
.END
