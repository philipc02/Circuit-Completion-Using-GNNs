* List of transistors:
* Q1, Q2, Q3, Q4, Q5, Q6, Q7

* Resistors
R1 7 2 10k
R2 4 6 0.8k
R3 5 6 0.8k
RE 8 4 500

* Transistors
Q1 2 2 7 NPN
Q2 2 4 2 NPN
Q3 4 4 4 NPN
Q4 4 4 8 NPN
Q5 8 4 3 NPN
Q6 5 3 5 NPN
Q7 3 6 5 NPN

* Voltage sources
V1 3 0 DC 5V
V2 7 0 DC 10V
V3 8 0 DC -10V

.END
