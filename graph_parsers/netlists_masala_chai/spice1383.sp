* SPICE Netlist
* NPN Transistors
Q_REF 2 2 3 NPN
Q_1 5 4 6 NPN

* Current Sources
I_REF 3 0 DC 1mA
I_copy 6 0 DC 1mA

* Voltage Source
V_CC 3 0 DC 5V

* Definitions
.model NPN NPN
