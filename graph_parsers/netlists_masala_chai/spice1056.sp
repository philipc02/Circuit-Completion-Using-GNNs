* SPICE Netlist
VCC 6 0 DC 2.5V

* Transistor
Q1 3 1 0 NPN

* Resistors
R1 4 6 1k
R2 6 2 13k
R3 2 5 12k
R4 3 0 400

* Capacitor
CB 2 5

* Voltage Input
VIN 3 0 DC 0V

* Output
VOUT 4

.MODEL NPN NPN
.END
