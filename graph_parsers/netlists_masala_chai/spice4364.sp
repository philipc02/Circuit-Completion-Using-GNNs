plaintext
* Differential Pair Amplifier Netlist

* Transistors
M1 3 7 5 5 NMOS
M2 3 2 5 5 NMOS

* Resistors
R1 6 4 RD_p
R2 4 3 RS_n
R3 3 5 RS

* Voltage Sources
V+ 6 0 DC VDD
V- 5 0 DC VSS

* Netlist end
