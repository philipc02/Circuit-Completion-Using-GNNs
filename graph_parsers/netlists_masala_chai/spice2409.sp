M1 4 3 2 2 NMOS
I1 2 5 DC <CURRENT_VALUE>
VDD 4 0 DC <VDD_VALUE>
Vin 3 0 DC <VIN_VALUE>
