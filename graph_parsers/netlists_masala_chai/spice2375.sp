spice
* SPICE Netlist
VDD 2 0 DC 1.8V
VSS 6 0 DC 0V

I1 3 2 DC 10uA
I2 12 2 DC 20uA
I3 10 2 DC 5uA
I4 6 2 DC 2.5uA
I5 6 2 DC 1.25uA

M1 2 5 5 5 PMOS L=1u W=20u
M2 5 12 2 2 PMOS L=1u W=40u
M3 3 12 2 2 PMOS L=1u W=80u
M4 5 13 12 12 PMOS L=1u W=10u
M5 12 13 2 2 PMOS L=1u W=160u
M6 5 10 13 13 PMOS L=1u W=5u
M7 13 10 2 2 PMOS L=1u W=20u

M8 10 2 6 6 NMOS L=1u W=128u
M9 10 2 8 8 NMOS L=1u W=64u
M10 6 2 6 6 NMOS L=1u W=32u
M11 8 2 6 6 NMOS L=1u W=16u
M12 6 2 6 6 NMOS L=1u W=8u
M13 8 2 6 6 NMOS L=1u W=4u

.END
