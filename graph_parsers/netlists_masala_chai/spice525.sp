spice
* NMOS Transistors
M21 5 3 8 8 NMOS
M22 5 5 8 8 NMOS
M25 6 5 8 8 NMOS

* PMOS Transistors
M23 5 5 2 2 PMOS
M24 2 5 2 2 PMOS

* Current Sources
I20 3 5 DC

* Supply Voltages
VDD 3 0 DC
VSS 8 0 DC

* Voltage Inputs
Vcm 5 0 DC
Vot1 3 0 DC
Vot2 3 0 DC

.end
