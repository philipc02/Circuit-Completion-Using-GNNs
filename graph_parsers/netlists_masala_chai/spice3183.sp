spice
* Transistor M3 (PMOS)
M3 5 8 2 2 PMOS

* Transistor M4 (NMOS)
M4 5 7 2 2 NMOS

* Transistor M5 (NMOS)
M5 2 8 2 2 NMOS

* BJT Q1
Q1 2 10 2 NPN

* BJT Q2
Q2 2 4 2 NPN

* BJT Q3
Q3 2 3 2 NPN

* Resistor R1
R1 7 2 R1_value

* Resistor R2
R2 2 6 R2_value

* Voltage source
VDD 5 0 DC VDD_value

* Output
Vout 6 0

* End of netlist
.end
