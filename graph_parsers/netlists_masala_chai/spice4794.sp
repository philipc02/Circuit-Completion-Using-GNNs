* BJT Amplifier Circuit
VCC 3 0 DC 16V
R1 3 4 1k
R2 5 0 200
R3 2 0 1k
Q1 6 5 0 NPN
Q2 4 6 0 NPN
* Connections
* Node 1 is Vin (B)
* Node 2 is Vout
* Node 0 is Ground
