spice
I1 6 5 DC li/f
R1 2 3 0  ; Represents connections from left to top right
R2 2 4 0  ; Represents connections from left to bottom right
V1 3 5 VO ; Voltage across the output
R3 4 5 0  ; Represents connections from bottom right
