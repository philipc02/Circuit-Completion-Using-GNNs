plaintext
* SPICE Netlist for the Annotated Schematic
V_T 5 3 DC 0
V_DD 6 3 DC VDD
V_SS 3 7 DC VSS
R_T 5 3 RT
R_D 6 2 RD
R_S 7 3 RS
C_O 2 3 CO
R_L 2 3 RL
M1 6 5 7 7 NMOS
