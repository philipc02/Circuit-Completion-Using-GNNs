spice
* Circuit Netlist

I1 9 2 DC 1A           * Current source
C1 7 2 1uF             * Capacitor
L1 6 4 1uH             * Inductor
RP 3 5 1k              * Resistor Rp
RL 3 2 1k              * Resistor Rl

* .END
