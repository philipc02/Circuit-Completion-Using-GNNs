plaintext
* SPICE Netlist

M1 3 2 8 8 NMOS
M2 7 2 8 8 NMOS
M3 4 2 1 1 PMOS
M4 4 2 1 1 PMOS
M5 6 4 9 9 PMOS
M6 11 4 1 1 PMOS
M7 8 5 5 5 NMOS
M8 10 5 5 5 PMOS
M9 3 9 5 5 NMOS
M10 10 7 1 1 PMOS
M11 3 9 5 5 NMOS
M12 12 7 8 8 PMOS

I_Q 8 5 DC

C_L 12 5

V_B1 7 5 DC
V_B2 10 5 DC
