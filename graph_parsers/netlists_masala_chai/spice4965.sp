spice
* NMOS Amplifier
VDD 2 0 DC 5V
RD 2 1 10k
RG 3 4 100k
RS 1 0 1k
M1 1 3 1 1 NMOS
