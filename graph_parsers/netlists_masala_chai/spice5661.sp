spice
* Diode Bridge Circuit
* Node numbers as per annotated diagram

I1 3 2 DC 1A
I2 3 5 DC 1A

Vi 6 5 DC 1V

D1 3 7 D_model
D2 5 7 D_model
D3 3 4 D_model
D4 5 4 D_model

R 4 2 10k

* Model
.model D_model D
