* Inductor Circuit Netlist
L1 1 4 8m
L2 4 6 4m
L3 3 4 2m
L4 5 3 4m
R1 2 6 0
R2 5 1 0
