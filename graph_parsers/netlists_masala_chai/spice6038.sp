spice
* Transistors
Q1 2 1 7 NPN
Q2 2 3 7 NPN
Q3 8 2 3 NPN
Q4 9 3 5 NPN
Q5 5 8 6 PNP
Q6 4 6 0 PNP
Q7 3 4 0 PNP

* Current Sources
I1 1 0 DC I
I2 2 0 DC I
I3 7 0 DC I

* Voltage Sources
VCC 1 0 DC VCC
VEE 0 4 DC VEE
VBIAS 3 5 DC VBIAS

* End of File
