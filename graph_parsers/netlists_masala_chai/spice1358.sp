spice
* Transistors
Q2 2 4 3 NPN
Q1 3 1 0 NPN

* Voltage Source
VCC 2 0 DC VCC_value

* Resistor
Rout 0 5 Rout_value

*Net Definitions
* 1: Vb2
* 2: VCC
* 3: Internal connection between Q2 and Q1
* 4: Vb1
* 5: Connection to load
