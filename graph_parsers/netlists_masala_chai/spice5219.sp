plaintext
* SPICE Netlist
C1 4 top C
C2 top 3 C
C3 top 6 2C
R1 top 6 R/2
R2 4 5 R
R3 3 6 R
Vin in 4
Vout 3 out
