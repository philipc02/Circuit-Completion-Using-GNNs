spice
* SPICE Netlist for the given circuit
R3 3 3B R3_value
RE1 3 5 RE1_value
RE2 5 6 RE2_value
Q1 6 4 2 Q1_model
R4 2 0 R4_value

.model Q1_model NPN
