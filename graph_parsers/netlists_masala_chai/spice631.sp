spice
* SPICE Netlist
Vsd 3 4 DC Vsd_value
R1 3 2 R1_value
Rd1 2 2 Rd_value
Rd2 2 2 Rd_value
Rd3 2 4 Rd_value
