* SPICE netlist for the given circuit

D1 2 3 D_model
R1 3 5 2.5k
V1 5 4 DC -5V

.model D_model D

.end
