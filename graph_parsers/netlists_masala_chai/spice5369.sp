spice
* SPICE netlist for the circuit

V1 2 8 DC 50V

R1 2 7 1k
R2 7 6 3.3k
R3 6 5 4.7k
R4 5 4 10k
R5 5 3 3.3k
R6 4 2 4.7k

.END
