plaintext
* Transistors
M1 4 1 6 6 NMOS
M2 3 2 6 6 NMOS
M3 2 2 1 1 PMOS
M4 2 3 1 1 PMOS
M5 2 4 5 5 NMOS

* Current Sources
Iss 6 0 DC 1mA
I1 4 0 DC 1mA

* Capacitor
Cc 3 4 1pF

* Voltage Source
VDD 1 0 DC 5V

* Input
Vin 1 0 AC 1V
