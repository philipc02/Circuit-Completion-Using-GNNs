spice
* Transistors
* Q1 terminals (Collector-Base-Emitter for BJT)

* Resistors
RS 7 5 1k
RE 2 0 10k
RC 9 4 6.5k
RL 6 3 5k

* Capacitors
C1 5 2 C1
C2 9 3 C2

* Voltage Sources
VS 8 7 DC V_S
VEE 2 0 DC 20
VCC 4 0 DC 25

* Output
RO 3 6 Ro

* Ground
V0 0 1 DC 0
