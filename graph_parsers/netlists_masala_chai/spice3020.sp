plaintext
* NMOS Transistors
M1 3 2 5 5 NMOS
M2 4 3 5 5 NMOS
M3 2 1 6 6 NMOS
M4 3 2 7 7 NMOS
M5 4 6 1 1 NMOS
M6 5 3 2 2 NMOS
M7 1 6 9 9 NMOS
M8 4 3 10 10 NMOS
Mb1 5 8 8 8 PMOS

* PMOS Transistor
Mb2 9 9 0 0 PMOS

* Current Sources
I_REF1 5 8 DC
I_REF2 6 9 DC

* Voltage Source
V_DD 9 0 DC
