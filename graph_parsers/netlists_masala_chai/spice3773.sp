plaintext
V1 7 5 DC Vi
G1 5 2 2 5 gm
R1 6 4 r1
R2 3 5 r2
