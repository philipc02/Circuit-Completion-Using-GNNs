* SPICE Netlist
V1 2 4 DC Vin
R1 2 3 R1
D1 3 4 D1
Vout 3 5
