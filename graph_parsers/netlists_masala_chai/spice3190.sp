* Nodes:
* 1 - Ground
* 2 - nA
* 3 - V_DD
* 4 - A
* 5 - X
* 6 - Y

* Transistors
M3 5 5 3 3 PMOS
M4 5 6 3 3 PMOS
Q1 4 4 1 NMOS
Q2 2 2 1 NMOS

* Resistors
R3 5 1 R3Value
R1 6 5 R1Value
R2 6 1 R2Value

* Voltage Source
VDD 3 1 DC V_DD_Value

* End of netlist
