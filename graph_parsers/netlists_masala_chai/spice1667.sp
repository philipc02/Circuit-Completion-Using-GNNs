spice
* Netlist for the given schematic
VThev 5 0 DC <value>
RThev 5 3 <value>
Cin 3 0 <value>
Cxy 3 2 <value>
Gm 2 0 VALUE={g_m * V(3,0)}
Cout 2 0 <value>
Rl 2 0 <value>
.end
