spice
* NMOS transistor
M1 6 2 4 4 NMOS

* Current Source
I1 6 2 IDC

* Voltage Source
V1 2 0 VREF

* End of Netlist
