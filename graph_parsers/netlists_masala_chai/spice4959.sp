* Example SPICE netlist
   .AC Vp-p 10mV
   V1 Vin 0 AC 10mV
   R1 Vin Vout 10k
   R2 Vout 0 200
   .END
