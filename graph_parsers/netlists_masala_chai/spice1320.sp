plaintext
* Op-Amp Circuit
Vin 1 4 DC 0
R1 2 2k
R2 3 1
XU1 1 4 2 OPAMP
.model OPAMP opamp

* Node Connections
* 1: Non-inverting terminal of Op-Amp
* 2: Output of Op-Amp
* 3: Node between R2 and the ground
* 4: Ground
