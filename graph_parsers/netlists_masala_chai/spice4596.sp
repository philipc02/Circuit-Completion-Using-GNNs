plaintext
* SPICE netlist for the circuit

VCC 10 0 DC 5V

I_E1 11 7 DC
I_E3 8 9 DC
I_E5 10 4 DC

R1 7 11 18k
R2 8 9 18k
R3 10 4 2.5k

Q1 6 7 4 NPN
Q2 3 6 4 NPN
Q3 8 5 4 NPN
Q4 2 5 4 NPN
Q5 4 3 0 NPN
Q6 4 2 0 NPN

.END
