plaintext
* NPN Transistor Amplifier Circuit
VCC 1 0 DC 15V
RB 3 3 200k
RC 1 4 1k
Q1 4 3 0 NPN
.model NPN NPN
