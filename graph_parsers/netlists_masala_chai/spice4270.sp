plaintext
* SPICE netlist for the given circuit

.IREF 8 4 DC 1mA

Q1 3 4 7 NPN
Q2 5 3 6 NPN

RE 6 2 1k

VCC 8 0 DC 15V

.END
