spice
* SPICE Netlist for the schematic

Vplus 4 0 DC 5V
Iref 5 0 DC 0.1A ; Current source value assumed for reference

Q1 4 5 5 NPN
Q2 2 4 3 NPN

R1 5 0 1k ; Resistor value assumed

.end
