plaintext
* Low Pass Filter Circuit

Vin in 0 DC 0 AC 1

C1 in out 5p
R1 out 0 2Meg

.end
