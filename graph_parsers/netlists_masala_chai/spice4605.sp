plaintext
V1 4 2 DC 72

R1 2 2 6k
R2 2 3 3k
R3 2 2 4k

RL A B 1k

* Note: Nodes 2 and 4 are used for connections as shown in the schematic.

.END
