plaintext
* SPICE netlist for the given circuit

R1 X 2 R1_value
R2 2 3 R2_value
V1 3 4 DC 0
