plaintext
R1 3 2 1k
D1 2 5 D
I1 6 5 DC 3A
