spice
* NMOS Transistor
M1 2 4 0 0 NMOS

* Capacitors
C1 Vin 4 <value_of_C1>
C2 2 Vout <value_of_C2>

* Resistor
RG 4 5 <value_of_RG>

* Voltage Source
VDD 5 0 <value_of_VDD>

* Current Source
I1 2 0 <value_of_I1>

* Net Definitions
Vout 2 0
Vin 1 0

* End
