plaintext
* Example SPICE Netlist
R1 5 7 100
D1 7 2 D
V1 2 4 DC 10
