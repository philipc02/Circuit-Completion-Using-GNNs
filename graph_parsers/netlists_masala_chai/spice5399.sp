plaintext
* SPICE Netlist for the provided schematic

Vs 3 6 AC 18 SIN(0 18 2k)
C1 2 4 0.1u
C2 7 4 0.22u
R1 7 3 470
R2 7 5 330
R3 5 8 680
*.end
