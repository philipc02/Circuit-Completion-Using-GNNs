plaintext
* SPICE Netlist for the given schematic

VDD 5 0 DC <voltage_value>
RD 1 5 <resistance_value>
M1 1 7 4 4 NMOS
M2 3 2 0 0 NMOS
Iin 6 4 DC <current_value>
