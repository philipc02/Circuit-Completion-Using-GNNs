spice
* NPN Transistor Amplifier Circuit

VCC 7 8 DC 18V
R1 4 6 1k
R2 6 8 1k
RC 3 7 2k
RE 2 8 1k

Q1 3 6 2 NPN

.END
