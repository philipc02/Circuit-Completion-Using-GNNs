spice
* SPICE Netlist
VCC 1 0 DC VCC
VEE 7 0 DC VEE

R1 1 3 R1
R2 3 7 R2
R3 5 2 R3
R4 4 2 R4

I_BIAS1 5 2 DC IBIAS1
I_BIAS2 4 6 DC IBIAS2

Q1 3 2 5 Q1_MODEL
Q2 6 2 4 Q2_MODEL

.model Q1_MODEL NPN
.model Q2_MODEL NPN

.end
