* SPICE Netlist
VDD 3 0 DC 5V
Iin 2 0 DC 1mA
I1 3 4 DC 1mA
M1 4 4 3 3 PMOS
M2 4 2 0 0 NMOS
