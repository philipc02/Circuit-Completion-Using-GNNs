spice
* Transistor Definitions
M1 2 1 0 0 NMOS
M2 5 4 0 0 NMOS
M3 2 3 4 4 PMOS
M4 2 3 5 5 PMOS

* Current Sources
I1 0 2 DC
I2 0 2 DC
I3 4 3 DC
I4 5 3 DC

* Voltage Sources
Vin1 1 0 DC
Vin2 4 0 DC

* Resistor
Rs 2 4 Rs_value

* End of Netlist
