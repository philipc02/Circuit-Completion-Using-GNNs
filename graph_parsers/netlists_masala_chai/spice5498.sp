spice
* NPN BJT Amplifier Circuit

VBB 5 6 DC 4V
VCC 2 3 DC 24V

RB 5 4 4.7k
RC 2 4 430

Q1 2 4 3 NPN

.END
