spice
* SPICE Netlist for the given circuit

* Resistors
R_RS 6 7 R_S
R_RI 7 3 R_i
R_RO 3 5 r_o
R_R 5 2 R

* Voltage Sources
V_V1 8 7 DC v1
V_VO 5 4 DC vo
V_VT 2 4 DC Vt

* Current Source with Transconductance
G_GM 8 5 3 0 G_m

* End of netlist
