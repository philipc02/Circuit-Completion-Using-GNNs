spice
* SPICE Netlist

* PMOS Transistor
M1 2 4 5 5 PMOS

* Current Source
I1 3 0 DC

* Voltage and Ground reference
V+ 3 0 DC
Vbias 2 0 DC
Vi 4 0 AC 1

* Output
Ro vo 3 R
