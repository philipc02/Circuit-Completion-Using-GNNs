spice
* SPICE netlist for the given circuit

Vs 3 2 AC 12 SIN(0 12 3k)
R1 3 6 180
L1 6 2 12m
L2 2 4 8m
C 3 4 <value_of_C_here>

.END
