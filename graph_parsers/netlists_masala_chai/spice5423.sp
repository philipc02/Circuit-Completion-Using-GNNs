* SPICE Netlist for the Circuit

Vs 1 8 SIN(0 10 5k)

L1 1 9 100m
R1 9 2 4.7k
R2 7 4 4.7k
R3 5 6 4.7k
R4 3 7 4.7k

L2 9 7 100m
L3 7 5 100m
L4 5 3 100m

* Ground connections
8 0
2 0
4 0
6 0

.end
