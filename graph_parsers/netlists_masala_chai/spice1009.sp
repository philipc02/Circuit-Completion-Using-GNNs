spice
* Q1 NPN Transistor
Q1 2 3 0 npn

* Resistors
R1 2 0 60k
R2 3 0 200

* Voltage Source
VCC 2 0 DC 2.5

* End of SPICE netlist
