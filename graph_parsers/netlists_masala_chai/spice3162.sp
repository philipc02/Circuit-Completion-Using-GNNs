spice
* Transistors
M1 2 7 8 8 NMOS L=0.32u W=45u
M2 4 2 8 8 NMOS L=40n W=5.6u
M3 2 5 5 5 NMOS L=80n W=6.3u
M4 6 2 2 2 NMOS L=0.32u W=45u
M5 3 5 6 6 PMOS L=80n W=6.3u
M6 4 3 6 6 PMOS L=80n W=6.3u
M9 5 3 6 6 NMOS L=80n W=5.1u
M10 6 4 7 7 NMOS L=80n W=5.1u
M11 8 5 9 9 NMOS L=40n W=113u
M12 9 7 8 8 NMOS L=160n W=1.25u

* Current Sources
I1 8 0 DC 113uA
I2 9 0 DC 2.5uA

* Capacitors
C1 4 3 50f
C2 6 7 50f

* Resistors
R1 6 4 8k
R2 7 0 160k

* Voltage Source
VDD 6 0 DC VDD

.END
