plaintext
* NPN Transistor Amplifier Circuit

VBB 3 5 DC 0V
VCC 7 5 DC 15V
RB 3 4 RESISTANCE_VALUE
RC 7 2 3k
Q1 2 4 5 NPN

.model NPN NPN (IS=1e-14 BF=100 VA=100)

.end
