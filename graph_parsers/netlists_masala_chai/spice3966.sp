Vs 9 3 DC
RS 9 8 0.5k
Rpi 8 2 r_pi
RE 7 3 RE
Ro 7 4 r_o
FbetaIb 0 2 Vdummy BETA

* Define a dummy voltage to use with the dependent current source
Vdummy 6 0 DC 0

* .MODEL statements and other necessary parameters can be added as needed
.END
