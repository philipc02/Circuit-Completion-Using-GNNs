plaintext
* SPICE netlist for the given circuit
G1 2 3 VGS 3 gm
R1 3 3 ro
R2 3 2 1/gm
VGS 3 2 DC 0
