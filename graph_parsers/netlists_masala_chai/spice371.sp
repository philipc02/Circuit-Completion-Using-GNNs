spice
* SPICE netlist for given schematic

V1 8 7 DC 0
I1 9 2 DC 0
R1 2 8 Ys
R2 2 3 g11vi
R3 3 2 g11a
R4 5 6 g22a
R5 6 2 g22f12vi
R6 5 3 ZL

.END
