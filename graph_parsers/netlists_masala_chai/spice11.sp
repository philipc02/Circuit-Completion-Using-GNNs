* SPICE Netlist
R1 1 2 300
R2 2 10 2.6k
R3 2 3 20M
R4 8 9 20k
R5 4 6 50
R6 10 11 5
C1 2 3 5.6f
C2 2 4 0.4p
C3 6 0 10.5f
V1 2 10 DC
I1 8 9 DC 38e-3
.ends
