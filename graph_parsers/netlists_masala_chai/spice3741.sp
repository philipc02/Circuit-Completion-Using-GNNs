plaintext
* SPICE Netlist
Vi 6 8 DC 0
Gm 2 4 2 8 gm
Ro 4 3 ro
RD 4 3 RD

* Nodes:
* 1 - Not used
* 2 - Connection for Vi, Gm
* 3 - Vds, Vo
* 4 - Connection for Gm, Ro, RD
* 6 - Positive terminal of Vi
* 7 - Not used
* 8 - Negative terminal of Vi and common ground
