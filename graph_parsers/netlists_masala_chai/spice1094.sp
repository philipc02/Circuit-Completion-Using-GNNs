spice
* Netlist for the circuit

* Voltage Sources
V1 4 0 DC 1V
V2 2 0 DC 0.2V
V3 2 0 DC 0.2V

* MOSFET
M1 2 4 0 0 NMOS

* End of Netlist
