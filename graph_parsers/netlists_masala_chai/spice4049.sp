plaintext
* Simple NPN Transistor Circuit

V1 3 0 DC Vi
RS 3 5 1000
RC 4 V+ 1000
RE 2 V- 1000
CE 2 0 10u

Q1 4 5 2 NPN

* Control Voltage
Vi 0 V+ DC 15
V2 0 V- DC -15

.end
