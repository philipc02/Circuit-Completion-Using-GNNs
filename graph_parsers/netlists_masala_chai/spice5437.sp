spice
* RLC Circuit

Vin 1 0 DC 0
C1 1 4 0.0047u
R1 4 3 50
L1 3 2 10m
R2 2 5 51
Vout 2 0 DC 0

* Ground node
Vg 5 0 DC 0

.END
