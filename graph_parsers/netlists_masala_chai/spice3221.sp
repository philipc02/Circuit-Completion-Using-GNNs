spice
* NMOS Transistor
M1 2 3 3 3 NMOS

* PMOS Transistor
M2 2 5 5 5 PMOS

* Capacitor
CH 2 4 CH_value

* Voltage/Current Sources and other elements can be added as required
