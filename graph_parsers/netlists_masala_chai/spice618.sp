spice
* Components
V1 3 0 DC 0
Iin 0 2 DC 0
R1 2 4 1k
D1 2 3 D
D2 4 3 D

* Model Definition
.model D D

.end
