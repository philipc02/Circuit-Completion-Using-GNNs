* Transistors
Q1 4 4 6 NPN
Q2 4 5 4 NPN
Q3 4 11 6 NPN
Q4 6 6 2 NPN
Q5 3 4 2 PNP
Q6 3 4 2 PNP
Q7 4 4 3 PNP
Q8 4 5 3 PNP
Q9 5 3 3 NPN
Q10 7 7 2 PNP
Q11 8 2 1 NPN
Q12 8 8 2 NPN

* Diodes
D1 9 8 D
D2 9 8 D

* Resistors
R1 2 4 1k
R2 4 11 1k
R3 7 2 1k
RL 8 0 1k

* Voltage Sources
V1 4 2 DC 15V
V2 4 3 DC -15V

* Current Source
I1 4 6 DC 1mA

.end
