* Transistors
Q1 5 6 3 NPN
Q2 2 7 4 NPN

* Resistors
R1 3 5 220
R2 3 6 220
R3 4 7 220
RL 2 3 16

* Voltage Sources
VCC 5 0 DC 30
Vin 7 0 AC

* End of Netlist
