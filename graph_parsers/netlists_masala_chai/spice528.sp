spice
* SPICE Netlist for the circuit

* Voltage Sources
VDD 9 0 DC VDD
VBIAS 7 6 DC VBIAS
VCSBIAS 5 0 DC VCSBIAS
VSS 8 0 DC VSS

* PMOS Transistors
M3 2 3 9 9 PMOS
M4 4 3 9 9 PMOS

* NMOS Transistor
M5 2 5 8 8 NMOS

* Node Assignments
* 1. Layout as guessed or assigned from schematics
*    according to your numbering system:
*      - Node 9 for VDD
*      - Node 7 for VBIAS
*      - Node 5 for VCSBIAS
*      - Node 8 for VSS
*      - Other nodes as per connection points in schematic
.end
