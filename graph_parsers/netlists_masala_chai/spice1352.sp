*SPICE Netlist
M1 2 4 3 3 NMOS_model
Rout 2 0 Rout_value
RoutA 3 0 RoutA_value
Vb 4 0 Vb_value

.model NMOS_model NMOS(Level=1)
