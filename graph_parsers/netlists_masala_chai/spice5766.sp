plaintext
* NPN Transistor Circuit
V1 1 0 DC 1.5
R1 1 3 2k
Q2 3 2 4 NPN
R2 4 5 2k
V2 5 0 DC 1.5
