plaintext
* Netlist for the given schematic

* Voltage Source
V1 1 5 DC 5

* Resistors
R1 1 2 3k
R2 2 3 2k
R3 2 5 2k
R4 3 5 2k

* Diode
D1 2 3 D

* Ground
V2 5 0 0

.model D D
