* SPICE Netlist
VPLUS 4 0 DC 5V
VMINUS 2 0 DC -5V
RE 4 2 R = {value} ; Specify value as needed
RB 4 3 10k
RC 2 5 R = {value} ; Specify value as needed
Q1 2 4 3 NPN
