spice
* SPICE Netlist
V1 7 3 DC 12
R1 7 6 6k
R2 6 5 4k
R3 5 4 4k
R4 4 A 4k
RL A 2 3k
R6 6 3 3k
R7 5 3 3k
R8 4 3 3k
.end
