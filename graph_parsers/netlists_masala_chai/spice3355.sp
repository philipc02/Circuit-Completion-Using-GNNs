spice
* SPICE Netlist
* Diodes
D1 7 6 Dmodel
D2 7 5 Dmodel

* Current Source
I1 6 5 DC 1.0

* Additional Model Definitions
.model Dmodel D

.end
