plaintext
* NMOS transistor
M1 3 V_i 2 2 NMOS

* Current source
I1 3 4 DC 100uA

* Capacitor CL
C1 3 2 0.5p

* Voltage source
V1 4 0 DC 2.5V

* Models
.model NMOS NMOS
