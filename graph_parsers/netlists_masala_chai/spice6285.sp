spice
* NMOS Transistor
MN1 3 4 6 6 NMOS

* Capacitor
C1 5 2 C

* Voltage Source
VDD 4 0 DC VDD_value
