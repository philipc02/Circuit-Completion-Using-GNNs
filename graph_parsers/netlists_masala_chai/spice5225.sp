spice
* SPICE Netlist

Q1 2 6 5 NPN

R1 8 2  R1_value
R2 6 7  R2_value
RE 5 3  RE_value

C1 2 3  C1_value
C2 3 4  C2_value
C3 6 8  C3_value
CE 5 3  CE_value

L1 2 8 RF_CHOKE_value

VCC 8 4 VCC_value
