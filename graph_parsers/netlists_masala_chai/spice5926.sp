spice
* Voltage Controlled Current Source
G1 5 4 vi 0 gm1

* Resistors
R_on 4 2 R_on
R_op 2 3 R_op

* Ground Connections
V_vi 5 0 0
V_gnd1 2 0 0
V_gnd2 3 0 0
