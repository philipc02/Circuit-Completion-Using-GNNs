* SPICE Netlist

* Resistors
R1 2 1 1k
R2 4 3 1k
R3 5 6 1k
RL 7 0 1k

* Capacitors
C1 1 2 1u
C2 7 4 1u
C3 5 0 1u

* Op-amp
XU1 3 2 4 OPAMP

* Voltage Sources
Vin 1 0 DC 0V
VCC 3 0 DC 15V

* End of Netlist
