plaintext
* SPICE Netlist for the given circuit
VCC 3 0 DC VCC

RB 4 2 RB
RC 3 VCC RC

Q1 3 4 0 QMODEL

.model QMODEL NPN
