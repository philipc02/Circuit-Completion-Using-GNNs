spice
* SPICE netlist for the schematic

Vin in 3 DC 0
D1 in 2 Dmodel
VB 2 0 DC 0
R1 in 2 1k
R2 2 0 1k

.model Dmodel D
