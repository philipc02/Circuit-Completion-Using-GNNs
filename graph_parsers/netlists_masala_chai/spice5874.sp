spice
*MOSFET Device
M1 4 3 2 2 NMOS

*Resistors
R_G1 3 3 1k
R_G2 3 2 1k
R_D 4 4 1k

*Voltage Source
V_DD 4 0 DC 5V

*.end
