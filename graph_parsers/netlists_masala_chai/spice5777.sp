spice
* BJT Circuit
V1 5 0 DC 5V
RB 2 2 1k
RC 5 3 1k
RE 2 4 1k
Q1 3 2 4 NPN
