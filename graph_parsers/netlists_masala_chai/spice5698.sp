plaintext
* PMOS Inverter Circuit

VDD 1 0 DC 2.5V
VSS 2 0 DC -2.5V

* PMOS Transistor
* Drain Gate Source
M1 3 2 1 1 PCH

* Resistor
R1 3 0 10k

* Voltage Source for Output
VOUT 3 0

.END
