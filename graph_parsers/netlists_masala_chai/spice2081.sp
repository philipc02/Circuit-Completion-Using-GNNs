spice
* SPICE Netlist
M1 4 4 2 NMOS
RD 3 4 1k
VDD 3 0 DC 5V
Vin 4 0 DC 0V

* Model Definitions
.model NMOS NMOS (LEVEL=1)
