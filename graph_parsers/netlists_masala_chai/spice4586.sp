* SPICE Netlist
* Components
M1 10 5 7 7 PMOS
M2 10 5 9 9 NMOS
M3 8 7 3 3 PMOS
M4 2 3 4 4 PMOS

R_C1 6 Vplus 1k
R_C2 6 2 1k
R_E 9 8 1.18k
R_3 3 8 1.5k
R_4 4 VOR 1.5k

Vsup Vplus 0 DC 5.2V
Vsup V' 0 DC -5.2V

* End of netlist
