plaintext
* SPICE netlist for the given BJT circuit

VCC 5 0 DC 15V

R1 5 4 20k
R2 3 0 10k

Q1 4 4 6 NPN
Q2 2 4 3 NPN

.END
