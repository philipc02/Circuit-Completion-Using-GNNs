spice
* Components
M1 2 1 3 3 NMOS
ro 4 2 RES
RL 2 3 RES
* Net Definitions
* 1 = Gate
* 2 = Drain
* 3 = Source
* 4 = VDD
