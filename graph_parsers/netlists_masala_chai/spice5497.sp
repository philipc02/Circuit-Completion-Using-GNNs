spice
* NPN Transistor Amplifier Circuit

Q1 2 3 5 npn
VBB 3 7 DC 10V
VCC 2 4 DC 20V
RE 5 6 10k

*.model npn NPN (IS=1E-14 BF=100)
.end
