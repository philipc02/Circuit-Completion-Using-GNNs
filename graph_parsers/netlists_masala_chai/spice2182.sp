M1 3 1 2 2 NMOS
ro 3 4 1000 ; Replace 1000 with actual resistor value if known
Rs 2 0 100  ; Replace 100 with actual resistor value if known
V1 1 0 DC 1 ; Replace "1" with actual voltage value if known
