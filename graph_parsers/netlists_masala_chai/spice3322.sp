spice
* NMOS Transistors
M1 3 5 5 5 NMOS
M2 3 4 5 5 NMOS
MN 6 26 2 2 NMOS

* Current Sources
I1 3 5 DC
I2 3 4 DC
IN 6 2 DC

* Resistors
R1 5 7 r
R2 5 5 r
RN 2 1 r

* Voltage Source
Vb 7 5 DC

* Ground
VGROUND 7 0 DC 0

* Models
.model NMOS NMOS
