spice
* NMOS Transistors
M1 1 1 3 3 NMOS
M2 3 2 2 2 NMOS
M3 2 3 2 2 NMOS
M4 2 6 2 2 NMOS

* Current Sources
I0 10 2 DC ID0
I1 4 2 DC ID1
I2 2 2 DC ID2
I3 6 2 DC ID3

* Resistors
R1 2 2 R
R2 2 2 R
R3 2 6 R
R4 6 2 R

* .model and .ends lines are not shown
