* Transistors
M1  9  2  9  9  PMOS
M11 4  3  2  2  NMOS
M12 2  3  4  2  NMOS
M13 2  2  10 2  PMOS
M14 2  2  9  2  PMOS
M15 4  5  3  2  NMOS
M16 2  2  6  2  NMOS
M17 2  2  10 2  PMOS

* Current Sources
I_BIAS 5  2  DC 1mA
I_TAIL 6  2  DC 1mA

* Voltage Sources
VDD 10  2  DC 5V
VSS 2  8  DC -5V

* Input Voltage
VI  3  2  DC 0V

* Output Voltage
VO  9  2
