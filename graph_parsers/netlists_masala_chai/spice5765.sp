spice
* BJT Amplifier Circuit
Q1 3 2 2 NPN
R1 2 1 2.7k
R2 2 4 2.7k
V1 1 0 DC 1.5V
V2 4 0 DC -1.5V

* Net definitions are as follows:
* 1: +1.5V
* 2: Connection to R1, R2, and BJT collector
* 3: Ground
* 4: -1.5V

.model NPN NPN
.end
