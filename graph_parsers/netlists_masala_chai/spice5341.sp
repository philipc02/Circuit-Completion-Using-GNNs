spice
* SPICE Netlist for the Resistor Network

V1 3 1 DC VS
R1 3 5 R1
R2 2 5 R2
R3 3 4 R3
R4 2 4 R4
RL 5 4 RL

* Define VS, resistors R1, R2, R3, R4, and RL
* Replace "VS", "R1", "R2", "R3", "R4", "RL" with values as needed

.END
