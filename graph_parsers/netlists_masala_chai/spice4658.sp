spice
* Inductor
L1 2 3 Vp

* Diodes
D1 4 5 D_model
D2 5 3 D_model

* Short Circuit
Vshort 4 3 0
