plaintext
* SPICE Netlist for the given schematic

VCC 2 0 DC 2.5V

R1 5 4 10k
R2 2 0 1k
R3 2 3 100

C1 1 5
C2 2 3

Q1 2 1 0 NPN

Vin 1 0

.end
