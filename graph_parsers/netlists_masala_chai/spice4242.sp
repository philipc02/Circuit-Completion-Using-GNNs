spice
* SPICE Netlist
* MOSFETs
M1 4 3 2 2 NMOS
M2 5 3 2 2 NMOS
M3 6 5 6 6 PMOS
M4 3 3 7 7 PMOS

* Current Source
IREF 3 1 DC

* Voltage Sources
V+ 1 0 DC
V- 2 0 DC

* IO connection
* Note: The connection for IO is identified by net 6.
