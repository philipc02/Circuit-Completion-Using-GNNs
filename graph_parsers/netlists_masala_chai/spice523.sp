spice
* Transistor Definitions
M21 3 6 7 7 NMOS
M22 5 4 7 7 NMOS
M23 7 6 7 7 NMOS
M24 9 4 7 7 NMOS
M25 2 8 8 8 PMOS

* Voltage Sources
Vdd 8 0 DC VDD
Vss 7 0 DC -VSS
Vcm 6 0 DC VCM
Vb 2 0 DC VB

* Output
Voc 0 9 DC
