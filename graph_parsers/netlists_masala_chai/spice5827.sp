plaintext
* SPICE Netlist for the given circuit
Vsig 5 8 DC 0
Rsig 5 3 R_sig
Rs 3 1 R_s
RD 2 1 R_D
Gm 2 3 3 4 1/gm
