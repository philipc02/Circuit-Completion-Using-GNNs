* SPICE Netlist
M1 2 4 7 7 NMOS
M2 3 5 7 7 NMOS
M3 8 3 9 9 PMOS
M4 8 3 5 5 PMOS
M5 8 5 35 35 PMOS
M6 8 6 35 35 PMOS

I_EE 7 0 DC

V1 1 0 DC
V2 2 0 DC

.model NMOS NMOS
.model PMOS PMOS
