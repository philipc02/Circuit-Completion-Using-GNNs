spice
* SPICE Netlist for Amplifier Circuit

VCC 4 0 DC VCC
VIN 5 0 AC 1

* Transistor
Q1 5 5 2 NPN

* Resistors
R1 4 5 R1
R2 5 7 R2
RC 4 3 RC
RE 2 6 RE
RL 3 0 RL

* Capacitors
C1 5 5 C1
C2 3 0 C2
C3 2 0 C3

* End of Netlist
