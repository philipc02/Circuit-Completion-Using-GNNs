I1 5 0 IBIAS
I2 2 3 {IOS/2}
V1 2 3 VOS
R1 3 4 Ri
R2 4 6 Ro
E1 0 4 3 0 {a(jω)}
