* Transistor Components
Q1 9 2 3 NPN
Q2 9 5 3 NPN

* Voltage Source
VCC 9 0 DC 15

* Voltage Source (Signal)
Vg 8 0 AC 10m

* Resistors
RG 4 8 5.1k
R1 6 9 150k
R2 2 8 150k
RE 3 0 470
RL 7 0 1k

* Capacitors
* Note: Capacitors not labeled, you can specify values if needed.
C1 2 4
C2 5 7

.end
