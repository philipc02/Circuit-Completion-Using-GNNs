plaintext
* Netlist for the given circuit
M1 2 4 3 3 NMOS
V1 4 0 DC Vx
R1 4 3 R1_value
I1 3 0 DC I1_value
V2 2 0 DC 2V
