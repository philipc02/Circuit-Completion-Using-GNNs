plaintext
* PMOS Transistors
MMPA 4 4 9 9 PMOS
MMPB 4 4 3 3 PMOS
MMPD 3 3 5 5 PMOS
MMPE 3 3 2 2 PMOS
MMPC 9 9 5 5 PMOS

* NMOS Transistors
MMNA 3 4 9 9 NMOS
MMNB 3 3 2 2 NMOS
MMNC 3 3 6 6 NMOS
MMND 2 2 7 7 NMOS
MMNE 2 2 8 8 NMOS

* Voltage Source
VVDD 4 0 DC VDD

* Node Definitions
* 0: Ground
* 4: VDD
* 9: Node connecting MPA and MPC
* 3: Node connecting MPB, MNA, and MNB
* 5: Intermediate node connecting MPC, MPD
* 2: Node connecting MNB, MND, and MNE
* 6: Node connecting MNC
* 7: Node connecting MND
* 8: Node connecting MNE
* VO: Output node

.end
