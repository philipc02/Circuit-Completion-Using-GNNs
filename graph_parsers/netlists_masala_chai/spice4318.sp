* SPICE Netlist

Q1 2 2 3 npn
Q2 2 2 3 npn
IBias 2 3 DC 1mA

* End of netlist
