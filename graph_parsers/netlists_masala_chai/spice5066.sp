plaintext
* Differential amplifier

Q1 3 5 6 NPN
Q2 2 1 6 NPN

RC1 5 7 180k
RC2 1 7 180k
RE 6 8 270k

VCC 7 0 DC 15V
VEE 8 0 DC -15V

.model NPN NPN
.END
