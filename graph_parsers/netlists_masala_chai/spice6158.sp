spice
* Op-amp Circuit

* Voltage Source
Vs 3 6 DC

* Resistors
R1 2 6 10k
R2 2 4 100k

* Op-amp
XU1 2 3 5 opamp

* Node Definitions
* 2: Input of op-amp
* 3: Positive terminal of Vs
* 4: Feedback loop
* 5: Output (Vo)
* 6: Ground

* End of Netlist
