plaintext
* JFET Amplifier Circuit
VDD 3 0 DC 30V
RD 3 4 2k
RG 2 0 1Meg
RS 5 0 Rs
J1 4 2 5 JFET_Model
.model JFET_Model NJF (IS=10mA VP=4V)
