spice
V1 9 8 DC V_id
I1 2 3 DC g_m*v_gs
R1 10 0 R_S
R2 3 4 R_L
