V1 1 4 DC 15
V2 5 4 DC 15
R1 2 3  R1_value
R2 3 4  R2_value
