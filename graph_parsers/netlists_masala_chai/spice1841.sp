plaintext
* SPICE Netlist
M1 3 4 4 4 NMOS
M2 2 2 4 4 PMOS
Iin 4 0 DC
I1 2 3 DC
VDD 2 0 DC
