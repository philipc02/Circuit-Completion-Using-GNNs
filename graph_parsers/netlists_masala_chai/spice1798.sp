spice
* Voltage Source VA
VA 2 8 DC <value>

* Dependent Voltage-Controlled Current Source Gm
Gm 5 4 2 0 <Gm_value>

* Resistor Rout
Rout 5 4 <Rout_value>

* Voltage Source Vx
Vx 6 3 DC <value>

* Current Source Ix
Ix 5 6 DC <value>

* Block K (transfer function)
H1 4 7 Vx <K_value>

.end
