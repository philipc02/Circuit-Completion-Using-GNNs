* SPICE netlist for the given schematic
Iin 6 4 DC <value_of_Iin>
Vbe 6 8 DC <value_of_Vbe>
Rpi 6 7 R_π
RF 1 2 R_F
ro 2 8 R_o
RC 2 3 R_C
Gm 5 8 6 8 gm
Vout 2 3 DC 0
