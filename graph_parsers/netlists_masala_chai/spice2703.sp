* Transistors
M1 2 7 4 4 NMOS
M2 2 7 5 5 PMOS

* Voltage Source
VDD 5 0 DC <Value>

* End of netlist
