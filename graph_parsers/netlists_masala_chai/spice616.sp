plaintext
* SPICE netlist
Vin 4 0 DC 0V
R1 4 3 1k
R2 3 2 1k
D1 3 2 D_Model
Vout 3 0

.model D_Model D
.end
