spice
* SPICE netlist for the given circuit
Vi 5 6 DC 0
RS 5 2 1k
M1 3 2 6 6 NMOS
RL 3 4 1k
