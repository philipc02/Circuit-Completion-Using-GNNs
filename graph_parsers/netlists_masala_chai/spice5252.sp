plaintext
* SPICE Netlist for Simple Circuit

V1 4 2 DC 5V      * Voltage Source from node 4 to node 2
R1 5 6 1k         * Resistor between nodes 5 and 6
V2 3 2 DC 0V      * Voltage across nodes 3 and 2 (measurement device)

.end
