spice
*MOSFET and Capacitor Circuit

* NMOS Transistor
M1 Vout CK Vin0 Vin0 NMOS

* Capacitor
CH Vout 0 <value>

* Voltage Sources
VCK CK 0 <CK_value>
Vin Vin0 0 <Vin_value>

.model NMOS NMOS
