plaintext
* SPICE netlist for the given circuit

* Voltage Source
VTH 4 5 DC <value>

* Resistors
R0 4 3 <value>
RL 3 6 <value>

.end
