* Inductor
L1 4 5 L_P

* Resistor
R1 4 3 R_P

.END
