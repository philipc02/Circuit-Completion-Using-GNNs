plaintext
* SPICE Netlist
R1 A 4 1k
R2 4 5 1k
R3 5 3 1k
R4 3 B 1k
.END
