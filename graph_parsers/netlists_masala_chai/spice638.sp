plaintext
* SPICE Netlist
V1 5 3 DC Vin
V2 4 33 DC Vout
D1 2 3 Dmodel
D2 2 5 Dmodel
R1 4 2 RL_value

.model Dmodel D
.end
