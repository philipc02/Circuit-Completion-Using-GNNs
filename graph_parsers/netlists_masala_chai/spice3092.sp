plaintext
* SPICE Netlist for the given schematic

M1 4 8 7 7 NMOS
M2 5 6 7 7 NMOS
M3 3 3 7 7 NMOS
M4 5 3 7 7 NMOS
M5 5 3 3 3 NMOS
M6 22 2 5 5 PMOS
M7 22 4 12 12 PMOS

VDD 22 0 DC 1.8V
Vin 8 0 DC 0V
Vb 2 0 DC 0V

.end
