spice
* Diode and resistor circuit

V1 2 0 DC 0
V2 3 0 DC 0
D1 2 2 Dmodel
D2 3 2 Dmodel
R1 2 5 R
V0 5 0 DC 0

.model Dmodel D
.end
