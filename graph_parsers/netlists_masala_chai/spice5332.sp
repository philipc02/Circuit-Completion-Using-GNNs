plaintext
* Schematic Netlist
V1 3 5 DC 10V
R1 2 4 1k
R2 4 6 1k
RL 4 7 RL_value

* Voltage source ground connection
V0 5 0 DC 0V

* Node connections
* Node 4: VOUT

.END
