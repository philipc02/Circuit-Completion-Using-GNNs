spice
* SPICE netlist for the given schematic

* Voltage Source
VDD 3 0 DC VDD

* Input
Vin 4 0 DC Vin

* Capacitors
C1 4 2 Ci
CL 2 0 CL

* Resistor
R1 3 2 R1

* NMOS Transistor
M1 2 3 0 0 NMOS

* Current Source
I1 2 0 DC I1

* End of netlist
