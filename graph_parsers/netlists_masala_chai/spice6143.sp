plaintext
* SPICE Netlist for the Schematic

Vsig 8 10 DC 0V
Rsig 6 8 10k
Cin 6 2 1u
Rb 2 9 100k
Rc 0 1.5V 5k
Cout 0 3 1u
RL 3 4 10k

Q1 0 9 2 NPN

.ends
