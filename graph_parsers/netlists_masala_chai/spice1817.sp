spice
* Netlist for the circuit

M1 2 5 3 3 NMOS
M2 2 5 4 4 PMOS
RD 2 VDD 10k
RF 2 4 10k
RM 4 0 10k

Iin 3 0 DC 1mA

VDD VDD 0 DC 5V
