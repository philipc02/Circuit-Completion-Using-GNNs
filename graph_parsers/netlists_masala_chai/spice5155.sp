plaintext
* SPICE Netlist for the given circuit

* Voltage source
V1 6 0 DC Vin

* Resistors
R1 2 0 R1
R2 5 2 R2
R3 6 3 R
R4 3 2 R

* Capacitors
C1 3 2 C

* Op-amp
XU1 2 3 5 OPAMP

* Control directives
.OP
.END
