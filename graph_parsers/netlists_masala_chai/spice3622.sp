plaintext
* SPICE netlist
V1 5 7 AC 1
C1 3 2 1u
D1 6 3 D
Rground 6 0 0
.end
