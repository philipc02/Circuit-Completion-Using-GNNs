spice
* Netlist for the given schematic

Ib 4 3 DC
Rpi 4 3 gpi
Ibeta 2 5 DC

* Node connections
* Node 6 is the common ground
