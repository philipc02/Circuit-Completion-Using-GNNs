* Components
Q1 2 6 3 QNPN
Q2 2 3 4 QNPN
R1 6 2 70k
R2 3 6 6k
RC1 2 1 5k
RC2 2 7 5k
RE1 3 0 2.2k
RE2 4 8 1.5k
Ro 7 8 3
RL 8 9 10k
CC1 6 5 10u
CC2 7 9 10u
Vs 5 0 AC 1

* Voltage sources
Vcc 2 0 DC 5
Vee 3 0 DC -5

* Model Definitions
.model QNPN NPN
.ends
