spice
* Inverting Amplifier Circuit
V1 5 0 DC 0
R1 5 3 1k
Rf 3 8 10k
* Op-amp model using E source
E1 8 0 4 2 100k
C1 4 0 1u * Op-amp feedback capacitance for stability
.ends
