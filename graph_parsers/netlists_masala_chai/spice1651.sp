* NMOS Transistor
M1 2 1 5 5 NMOS

* Capacitors
Cgd 4 2 C_GD
Cgs 5 1 C_GS
Cdb 2 0 C_DB
Csb 5 0 C_SB

.model NMOS NMOS (Level=1)
