plaintext
V1 2 0 DC 3V
V2 3 0 DC 1.5V
R1 2 1 8.2k
R2 1 0 4.7k
Q4 1 3 0 QNPN
.model QNPN NPN
