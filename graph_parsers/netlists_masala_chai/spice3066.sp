plaintext
* PMOS Transistors
M3 6 7 5 5 PMOS
M4 6 2 5 5 PMOS

* Resistors
RF1 7 5 R
RF2 3 5 R

* Current Source
I1 5 9 DC 1

* Voltage Supply
VDD 6 9 DC VDD

* End of Netlist
.END
