spice
* SPICE Netlist
VOS 3 2 DC 0

R1 1 2 1k
R2 6 3 1k
R3 4 2 1k

Q1 6 5 2 QNPN
Q2 3 5 4 QNPN

* Model Definitions
.model QNPN NPN
