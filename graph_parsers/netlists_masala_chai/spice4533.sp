* Operational Amplifier Circuit
R1 2 7 R1
R2 2 5 R2
R3 3 6 R
C1 3 4 C
C2 2 4 C
V1 7 0 DC 0
VOUT 5 55 DC 0
.OPAMP 3 2 0 55
.END
