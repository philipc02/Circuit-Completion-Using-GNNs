spice
* SPICE Netlist

* NMOS Transistors
M1 4 3 0 0 NMOS
M2 2 7 5 5 NMOS

* Current Source
I1 7 6 DC I_i

* Voltage/Current Definitions
V0 2 0 DC 0
