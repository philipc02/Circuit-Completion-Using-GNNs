spice
* SPICE Netlist

VCC 3 0 DC 2.5V
VIN 1 0 AC 1V

RS 1 4 1k

Q1 2 4 0 NPN

I1 2 0 DC 0.1A

* End of Netlist
