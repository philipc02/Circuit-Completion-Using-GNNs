spice
* SPICE Netlist
V_in 6 4 DC 0
R1 6 5 1k
D1 5 7 mod_d
D2 5 3 mod_d
VB1 7 4 DC 0.7
VB2 3 4 DC 0.7
.model mod_d D
