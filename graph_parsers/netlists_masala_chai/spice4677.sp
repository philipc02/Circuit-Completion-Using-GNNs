spice
* SPICE Netlist for the Given Circuit
Vin 5 0 AC 1
XL 5 6 L1
XC 6 0 C1
Vout 6 2 DC 0
