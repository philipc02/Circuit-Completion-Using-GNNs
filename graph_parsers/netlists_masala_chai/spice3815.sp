plaintext
Vi 3 0 DC
CC 3 5 1uF
IQ 5 8 DC 2mA
M1 5 5 0 0 NMOS
RD 4 6 1k
Vplus 4 0 DC 1.8V
Vminus 5 8 DC -1.8V
Vo 2 4 DC
