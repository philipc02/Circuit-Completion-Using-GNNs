* V_DD is node 2
* Ground is node 3

* MOSFETs
M1 7 4 8 8 NMOS
M2 5 7 3 3 NMOS
M3 2 7 4 2 PMOS

* Current Source
I_REF 2 5 DC

* Resistor
R1 2 4 1000

* Voltage Source
V1 4 3 DC 5
