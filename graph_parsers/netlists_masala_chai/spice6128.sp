* Example SPICE Netlist

* Resistor
Rsig 5 3 Rsig_value
RL 6 2 RL_value

* Capacitors
Cmu1 3 8 Cmu1_value
Cpi1 3 2 Cpi1_value
Cmu2 2 4 Cmu2_value
Cpi2 2 4 Cpi2_value

* Transistors
Q1 3 5 2 Q1_model
Q2 2 6 4 Q2_model

* Ground nodes
Vground1 8 0 0
Vground2 3 0 0
Vground3 4 0 0

* End of netlist
