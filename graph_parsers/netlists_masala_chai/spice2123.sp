plaintext
* NMOS Transistor
M1 3 4 2 2 NMOS_MODEL

* Resistor
RD 3 3 RD_VALUE

* Current Source
I1 5 2 VALUE=1/gm2

* Voltage Input
Vin 4 0 DC Vin_VALUE

* Load GND
Vout 3 0 DC 0
