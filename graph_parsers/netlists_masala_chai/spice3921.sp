plaintext
* Transistor
Q1 4 3 2 NPN

* Resistors
R1 1 4 500k
R2 4 5 70k
R3 4 6 500k
R4 6 0 50k
R5 2 0 5k

* Voltage Sources
V1 1 0 DC 3V
V2 6 0 DC 5V
V3 3 0 DC 15V
V4 5 0 DC -5V
V5 2 0 DC -5V

* End of netlist
