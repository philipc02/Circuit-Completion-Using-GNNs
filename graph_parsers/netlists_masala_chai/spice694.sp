spice
* SPICE Netlist
Vin 5 6 DC 0
R1 5 3 R
R2 3 2 R
D1 2 4 D
Vout 4 6 DC 0

* Model statement for diode
.model D D

.end
