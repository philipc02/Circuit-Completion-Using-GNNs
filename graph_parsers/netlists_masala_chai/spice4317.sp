plaintext
* SPICE Netlist
M1 5 9 9 9 NMOS
M2 7 11 9 9 NMOS
M3 2 6 5 5 PMOS
M4 7 6 5 5 PMOS
M5 3 2 2 2 PMOS
M6 7 2 3 3 PMOS
M7 10 2 2 2 PMOS
M8 4 2 10 10 PMOS

I_Q 5 V- DC VALUE
