spice
* SPICE Netlist
Vi 1 0 DC 0
RS 1 6 10k
CC1 2 3 0.1u
R1 3 4 51k
R2 3 2 5.5k
RC 3 4 10k
RF 5 6 82k
RE 3 7 0.5k
CC2 3 5 0.1u
CE 2 0 0.1u
Vcc 4 0 DC 10

* .end
