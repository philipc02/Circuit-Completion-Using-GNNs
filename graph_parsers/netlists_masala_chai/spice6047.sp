spice
* SPICE Netlist
Q8 3 5 4 NPN
R6 4 2 1k
VCC 3 2 DC 10V
V0 v_out 4 DC 0V
