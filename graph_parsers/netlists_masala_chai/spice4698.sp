* Schematic Netlist
V1 4 6 AC 1
R1 4 5 Rs
D1 5 2 LED
D2 7 3 RECTIFIER
