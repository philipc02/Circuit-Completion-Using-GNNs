plaintext
* MOSFETs
M1 2 7 10 10 NMOS
M2 3 6 7 7 NMOS
M3 5 5 2 2 PMOS
M4 5 2 2 2 PMOS
M5 3 5 4 4 PMOS

* Resistors
R1 2 7 R1_value
R2 3 6 R2_value

* Voltage Sources
VDD 5 0 VDD_value
