spice
* NPN Transistor Amplifier Circuit
Q1 2 Vin 0 NPN

* Resistors
RC 2 Vout 10k
RE 0 0 1k

* Voltage Sources
VCC VCC 2 DC 10V
Vin Vin 0 DC 1V

* Simulation Control
.tran 1ms 10ms
.end
