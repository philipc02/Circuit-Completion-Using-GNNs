* NMOS Transistor
M1 3 2 5 5 NMOS

* Current Source
I1 4 3 DC I

* Voltage Source for V_DD
VDD 4 0 DC VDD

* Connections
V_GND 5 0 DC 0

* Input Voltage Source
VI 2 0 DC vi
