plaintext
* SPICE Netlist

V1 4 5 DC 0
R1 3 3 100k
C1 2 6 10p

.END
