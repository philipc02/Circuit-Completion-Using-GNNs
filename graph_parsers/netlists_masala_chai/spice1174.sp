spice
* SPICE netlist for the schematic
M1 N_Rout Vb N_M2_D NMOS
M2 N_M2_D N_M2_D 0 NMOS
Iout N_Rout 0 DC 1mA
