*SPICE Netlist

I1 2 6 DC 1A
D1 6 3 Dmodel
V1 3 3 0 DC 0V
C1 6 3 10nF

.model Dmodel D
