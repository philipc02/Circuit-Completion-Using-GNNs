spice
* Voltage source
V1 4 5 DC

* Resistor
R1 4 2 1k

* Diode
D1 2 5 Dmodel

* Voltage source for biasing
V2 6 5 DC 1

.model Dmodel D
