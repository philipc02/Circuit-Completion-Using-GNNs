spice
* SPICE Netlist
VDD 4 0 DC VDD_value
RP1 4 5 RP1_value
RTG 5 3 RTG_value
Cout1 5 6 Cout1_value
CTG1 5 5 CTG1_value
CTG2 2 2 CTG2_value
Cin2 3 3 Cin2_value
