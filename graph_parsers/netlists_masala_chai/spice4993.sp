plaintext
* SPICE Netlist for the given schematic

Vin 8 0 AC 1

M1 4 3 2 2 NMOS

RD 4 5 1k
RG 3 8 1k
RL 5 0 1k

Cin 8 3 1u
Cout 5 9 1u

VDD 4 0 DC 5

.END
