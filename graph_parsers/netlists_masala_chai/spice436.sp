spice
* Voltage Source
V1 1 2 DC Vin

* Resistors
R0 3 2 R0
R1 5 4 R1
R2 6 8 R2

* Capacitors
C0 3 2 C0
C1 5 2 C1
C2 8 2 C2
Cn1 4 6 Cn1
Cn2 4 1 Cn2

* Current Sources
I1 3 2 DC gm0*V(1)
I2 5 2 DC gm1*V(1)
I3 8 2 DC gm2*V(2)
I4 6 2 DC gmy0*V(0)
I5 7 2 DC gmy1*V(1)
