spice
* Components
MN1 2 3 0 0 M1
V1 3 0 VIN
IB 2 0 Ib
LP 2 6 LP
RP 6 0 RP
CP 6 4 CP
C2 2 0 C2
VDD 4 0 DC VDD

* Net Definitions
* 1: GND
* 2: X
* 3: Vin
* 4: VDD
* 5: LP terminal
* 6: CP & RP terminal

* End of Netlist
