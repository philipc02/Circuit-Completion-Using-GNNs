spice
* Circuit Netlist

V1 3 4 DC 25V
R1 4 2 1k
R2 2 3 3.9k
R3 5 3 560

.END
