* Component Declaration
Vi 5 0 DC 0
Vdd 7 0 DC 10V
Rin 5 2 1k
R1 2 7 10k
R2 2 8 5k
R0 4 0 10k
Rs 6 8 500
RL 6 0 1k
Cc1 5 2 1uF
Cc2 4 6 1uF

* Analysis Commands
.op

* End of netlist
.end
