* SPICE Netlist for the given schematic

V1 1 0 DC 12V
R1 2 7 1MEG

* PMOS Q1
M1 4 2 1 1 PMOS_MODEL

* NMOS Q2
M2 4 2 3 3 NMOS_MODEL

.END
