* SPICE Netlist for the given circuit

Vin 1 0 DC 0
R1 5 2 1k
D1 4 2 D
VB 2 3 DC 0
R2 2 0 1k

.model D D
