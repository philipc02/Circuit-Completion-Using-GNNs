* NMOS Transistors
M1 2 2 28 28 NMOS
M2 4 3 5 5 NMOS
M3 5 4 7 7 NMOS

* PMOS Transistor
M4 4 4 6 6 PMOS

* Current Sources
I1 2 0 DC I1
I2 7 0 DC I2
I3 6 0 DC I3
I4 28 0 DC 2I1
I5 5 0 DC 2I2

* Capacitors
C1 4 3 Cm1
C2 4 7 Cm2

* Voltage Sources
Vin 22 2 DC Vin
VBB 22 0 DC VBB

* Output
Vo 3 0
