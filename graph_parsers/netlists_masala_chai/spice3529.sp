* Nodes are labeled based on the annotated image

Q1 8 8 2 NMOS
Q2 5 4 3 NMOS
Q3 6 6 10 PMOS
Q4 7 6 10 PMOS
Q5 4 4 3 NMOS
Q6 3 6 10 PMOS

R2 3 10 1k

VIN1 8 0 DC 0V
VIN2 5 0 DC 0V
IBIAS1 2 22 DC 10uA
IBIAS2 3 2 DC 10uA

VDD 10 0 DC 5V
VSS 2 0 DC -5V

.MODEL NMOS NMOS (LEVEL=1)
.MODEL PMOS PMOS (LEVEL=1)
.END
