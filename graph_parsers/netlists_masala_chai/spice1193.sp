plaintext
* Simple Inverter Circuit

M1 Vout Vin VDD VDD PMOS
M2 Vout Vb 0 0 NMOS

VDD VDD 0 DC 3.3
VGG Vin 0 DC 1.65
VBB Vb 0 DC 0

* End of Netlist
