spice
* Transistors
Q1 6 5 10 NPN
Q2 4 3 10 NPN
Q3 7 5 6 NPN
Q4 9 3 6 NPN
Q5 7 4 9 NPN

* Current Sources
I1 7 6 DC 0
IC4 9 6 DC 0

* Resistors
R1 7 6 8.5k
RC1 9 6 2k
RC2 7 6 2k

* Voltage Sources
V1 6 0 DC 5V
V2 10 0 DC -5V

.END
