* SPICE Netlist for the Circuit

I1 3 0 DC 5mA
V1 1 0 DC 10V
V2 2 0 DC 5V
V3 4 0 DC -5V
R1 2 3 2k
R2 3 4 1k
D1 2 3 D
D2 3 4 D

.model D D

.ends
