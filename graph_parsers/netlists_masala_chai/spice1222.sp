spice
* SPICE Netlist

* PMOS Transistor
M1 3 4 2 2 PMOS_MODEL

* Voltage Source V_B1
V_B1 4 5 DC VALUE

* Voltage Source Vx
Vx 2 3 DC VALUE

* Component & Model Definitions
.MODEL PMOS_MODEL PMOS
