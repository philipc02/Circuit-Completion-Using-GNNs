spice
* SPICE Netlist
VCC 5 0 DC 3.5V
RY 1 5 8k
RC1 6 5 1k
RC2 5 7 1k
RE 3 0 12k
QY 2 1 5 QMODEL
QX 3 2 4 QMODEL
Q1 2 6 3 QMODEL
Q2 3 7 8 QMODEL
D1 4 6 DMODEL
D2 7 5 DMODEL

.model QMODEL NPN
.model DMODEL D
