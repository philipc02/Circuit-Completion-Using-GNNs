* Wheatstone Bridge Circuit

V1 6 3 DC 10  ; Voltage source of 10V

R1 6 2 1000   ; Resistor R1 with 1k ohms
R2 2 4 1000   ; Resistor R2 with 1k ohms
R3 3 5 1000   ; Resistor R3 with 1k ohms
R4 5 4 1000   ; Resistor R4 with 1k ohms

* Output voltage node
* VOUT is between node A (5) and node B (2)

.end
