spice
* BJT Amplifier Circuit
VTH 3 6 DC <VTH_VALUE>
VCC 2 6 DC <VCC_VALUE>
RTH 3 3 <RTH_VALUE>
RC 4 2 <RC_VALUE>
RE 5 6 <RE_VALUE>
Q1 4 3 5 NPN  ; Collector, Base, Emitter

.model NPN NPN
.END
