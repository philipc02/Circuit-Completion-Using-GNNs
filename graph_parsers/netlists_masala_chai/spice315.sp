spice
V1 4 0 DC {V_S}
RS 4 3 {R_S}
M1 3 4 0 0 NMOS
R2 3 3 {R_2}
M2 3 2 0 0 NMOS
RL 2 0 {R_L}
