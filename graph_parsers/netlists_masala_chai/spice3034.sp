spice
* MOSFET Devices
M1 3 4 5 5 NMOS
M2 8 4 3 3 NMOS
M3 3 6 10 10 NMOS
M4 10 9 3 3 NMOS
M5 9 3 22 22 PMOS
M6 3 3 22 22 PMOS
M7 10 3 7 7 NMOS
M8 7 6 3 3 NMOS
M9 7 3 3 3 NMOS
M10 3 3 3 3 NMOS
Mb1 3 3 33 33 PMOS
Mb2 3 3 33 33 PMOS
Mb3 3 3 33 33 PMOS

* Current Sources
IREF1 33 3 DC <value>
IREF2 3 22 DC <value>
IREF3 3 3 DC <value>

* Voltage Sources
VDD 22 0 DC <value>
Vin 4 0 AC <value>
Vb1 5 0 DC <value>
Vb2 6 0 DC <value>

*End of SPICE Netlist
