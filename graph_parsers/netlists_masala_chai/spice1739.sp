spice
* SPICE Netlist
M1 2 Vin 0 0 NMOS
M2 Vout 2 VDD VDD PMOS
Rs Vin 2 1000
VDD VDD 0 DC 5
Vin Vin 0 DC 1
