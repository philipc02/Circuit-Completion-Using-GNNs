spice
* Components
V1 6 4 DC Vps
R1 4 2 R1
R2 2 3 R2
D1 5 3 D

* Connections
* Node 1: V1 to R1
* Node 2: R1 to R2
* Node 3: R2 to Ground
* Node 4: V1 positive terminal
* Node 5: Diode D
* Node 6: Vps
