spice
* Low Pass RC Filter
VIN 1 0 DC 0
R1 2 0 R
C1 1 2 C
VOUT 2 4

* The nodes are defined as follows:
* 1: Input voltage node (vI)
* 2: Common node between the resistor and capacitor
* 0: Ground
* 4: Output voltage node (vO)

.END
