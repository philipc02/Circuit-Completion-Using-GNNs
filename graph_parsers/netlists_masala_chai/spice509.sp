spice
* NPN transistor circuit
Q1 3 4 2 NPN
Is 4 0 DC 1A
Rs 4 0 1k
R1 6 3 10k
R2 3 5 10k
Vout 5 0
