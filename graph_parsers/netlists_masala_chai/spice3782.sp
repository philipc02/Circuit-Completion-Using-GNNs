plaintext
* SPICE Netlist for the Given Schematic

* NMOS Transistor
M1 4 5 3 3 NMOS_MODEL

* Voltage Sources
V1 6 5 DC Vi
VGS 7 0 DC Vgs
VDD 2 0 DC Vdd

* Resistor
RD 2 4 RD_VALUE

* End of Netlist
