spice
* NPN Transistor Circuit
Q1 4 4 3 QNPN

* Resistors
RC 2 4 RC
RB 3 4 RB

* Voltage Source
VCC 2 0 VCC
VIN 3 0 VIN

.model QNPN NPN
