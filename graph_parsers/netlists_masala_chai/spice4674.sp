spice
* SPICE Netlist
V1 5 4 AC 1V
C1 5 3 1uF
D1 3 2 D
RL 3 2 1k
.ends
