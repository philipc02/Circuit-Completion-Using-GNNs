spice
* SPICE netlist for the given schematic

Q2 3 4 8 QMOD
RL 5 3 10k
ZE1 8 6 5k
I2 4 6 DC 1mA

* Model declarations
.model QMOD NPN
