plaintext
* SPICE Netlist for the Circuit

VBB 1 0 DC 5V
VCC 4 0 DC 5V
RB 1 2 680k
RC 4 3 470
Q1 3 2 0 NPN

.END
