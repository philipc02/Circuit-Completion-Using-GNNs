plaintext
* SPICE Netlist for the given circuit
V1 5 2 DC 24
R1 5 4 330
R2 4 6 680
R3 3 2 680
R4 2 6 560
RL 3 4 1k
.END
