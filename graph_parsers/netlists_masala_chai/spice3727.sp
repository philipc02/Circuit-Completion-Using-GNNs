spice
* PMOS Transistor M2
M2 2 4 3 3 PMOS

* NMOS Transistor M1
M1 2 6 5 5 NMOS

* Voltage Source
VDD 3 0 DC 5V

* Input voltage source
Vin 6 0 DC 0V

* Analysis
.END
