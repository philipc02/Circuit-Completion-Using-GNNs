plaintext
V1 3 0 DC <VG_VALUE>    ; VG source
V2 2 3 DC <VTH_VALUE>   ; VTH source between net 2 and net 3
V3 2 0 DC <VD_VALUE>    ; VD source

M1 2 3 0 0 NMOS_MODEL   ; NMOS transistor
