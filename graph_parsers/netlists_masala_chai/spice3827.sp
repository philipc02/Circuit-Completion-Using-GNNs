spice
* NMOS Transistors
M1 6 3 4 4 NMOS
M2 2 9 10 10 NMOS

* Voltage Sources
V1 7 0 DC vi
VDD 11 0 DC VDD

* Resistors
R1 11 6 R1
R2 6 5 R2
RS1 4 0 RS1
RS2 2 0 RS2
RD1 11 6 RD1
RD2 11 2 RD2

* Capacitors
CC 7 5 CC
CS1 4 3 CS1
CS2 2 3 CS2

* End of netlist
