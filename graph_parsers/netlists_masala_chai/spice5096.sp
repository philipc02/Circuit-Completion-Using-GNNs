plaintext
* Op-Amp Circuit
* Voltage Sources
Vin 1 2 AC 1

* Resistors
Rf 5 2 100k
R1 2 0 2k

* Operational Amplifier
XU1 2 3 5 4 0 OPAMP

* Model definitions
.model OPAMP opamp(NoVCC)
