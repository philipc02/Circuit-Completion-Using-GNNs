spice
* NMOS Transistor
M1 3 2 2 2 NMOS

* Capacitor
C1 2 3 C_value

* Resistor
RD 3 5 R_value

* Voltage Source for Input
Vin 2 0 DC Vin_value

* Bias Voltage Source
Vb 4 0 DC Vb_value

* Supply Voltage Source
VDD 5 0 DC VDD_value

* Nodes
* 0: Ground
* 2: Vin and Ground
* 3: Vout, RD, and C1
* 4: Vb and Ground
* 5: VDD and RD
