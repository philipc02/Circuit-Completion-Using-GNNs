spice
* SPICE Netlist
R7 5 6 1k
R8 3 2 1k
R9 2 4 1k

* Connections
* Node 5: A, Top of R7
* Node 6: Bottom of R7
* Node 3: Connection between R7 and R8
* Node 2: Connection between R8 and R9
* Node 4: B, Bottom of R9
