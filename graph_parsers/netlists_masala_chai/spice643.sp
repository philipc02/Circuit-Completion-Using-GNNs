* Diodes and Components
D1 3 2 Dmodel
D2 4 7 Dmodel
D3 7 4 Dmodel
D4 4 2 Dmodel

* Inductor
L1 4 2 Lvalue

* Voltage Source
Vin 2 3 DC Vvalue

.model Dmodel D
