* SPICE Netlist
Q1 3 2 2 NPN
Q2 2 3 2 PNP
Vb1 2 0 DC <Value>
Vb2 3 0 DC <Value>
I1 6 7 DC <Value>
Rout 5 6 <Value>
