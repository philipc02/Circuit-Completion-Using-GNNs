spice
* Diode-Resistor Circuit
V1 3 2 DC 'V_in'
D1 3 3 D_model
R1 3 2 'R_value'

.model D_model D
.END
