spice
* Circuit Netlist
V1 6 2 AC 1
C1 2 6 470p
R1 6 4 2.2k
R2 2 3 1k
R3 3 5 1k
Vout 3 5 DC 0
* Ground connection
V2 5 0 DC 0
.END
