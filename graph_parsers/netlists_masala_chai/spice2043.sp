plaintext
*MOSFET NMOS
M2 4 2 4 4 NMOS

*Capacitor
CL 4 0 1uF

*Voltage Source
VDD 3 0 DC 5V

*Simulation Commands
.END
