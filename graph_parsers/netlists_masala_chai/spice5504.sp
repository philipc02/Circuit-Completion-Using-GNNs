plaintext
* NMOS Inverter Circuit
VDD 5 0 DC 5V
RD 5 6 1k
RG 2 0 1k
M1 6 2 4 4 NMOS
.model NMOS NMOS level=1
