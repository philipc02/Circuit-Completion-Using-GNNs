spice
* SPICE Netlist
Vin V_in 0 DC 1.0
X1 X Y opamp
D1 Y 2 D
R1 2 0 1k
.end
