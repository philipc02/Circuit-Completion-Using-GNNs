spice
* SPICE Netlist
C1 10 3 C
C2 6 6 C
C3 7 7 C
R1 3 8 R
R2 6 8 R
R3 7 8 R
E1 9 7 2 2 -K
