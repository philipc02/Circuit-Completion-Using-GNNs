spice
* SPICE Netlist
M1 6 7 5 5 NMOS W=W1 L=L
M2 4 6 8 8 NMOS W=W1 L=L

* Define Models
.model NMOS NMOS
