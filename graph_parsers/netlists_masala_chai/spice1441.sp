spice
* Netlist for the given schematic

* Transistors
Q1 4 2 5 NMOS
Q2 3 3 0 NMOS

* Current Source
I1 5 0 DC 1mA

* Resistor
Rp 2 3 1k

* Voltage Nodes
Vcc 5 0 DC 5V
Vb1 2 0 DC 2.5V
Vin 3 0 DC 1V

* Outputs
Vout 5

.end
