Vsig 5 7 DC
Rsig 5 2 Rsig
Q1 6 2 3 NPN
Ro 3 0 Ro
RL 3 Vo RL
