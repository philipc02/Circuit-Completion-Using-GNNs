spice
* SPICE netlist for the given circuit

Vin 4 3 DC 0V
R1 4 2 1k
C1 2 3 10uF
XOP 3 2 3 Vout opamp

* Include opamp model
.model opamp opamp
