spice
* BJT Transistor
Q1 2 6 4 NPN

* Current Sources
I1 0 2 DC 4mA
I2 4 3 DC 2mA

* Resistors
R1 2 3 1k
R2 2 4 1k

* Voltage Sources
V1 0 2 DC +5V
V2 3 0 DC -5V

* End of netlist
