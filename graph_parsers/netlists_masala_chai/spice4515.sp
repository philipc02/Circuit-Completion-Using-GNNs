spice
   Vgs 9 8 DC 0
   C1 3 7  C=C1_VALUE
   C2 5 8  C=C2_VALUE
   L 4 5   L=L_VALUE
   R 6 7   R=R_VALUE
   Gm 2 3  Vgs 8 GM=GM_VALUE
