spice
* SPICE netlist for the given circuit

V1 3 6 DC 15
R1 3 1 1k
R2 1 3 560
R3 3 2 470
R4 2 4 3.3k
R5 2 6 2.2k

.END
