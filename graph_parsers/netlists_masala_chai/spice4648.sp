spice
* Simple Diode Circuit

V1 2 0 DC 20V
D1 2 3 D_Model
RL 3 0 1k

.model D_Model D

*.end
