spice
* SPICE Netlist

VDD 3 0 DC 5

C1 2 3 CP
C2 2 3 CP

RP1 6 2 RP
RP2 7 2 RP

LP1 6 7 LP
LP2 2 3 LP

M1 2 4 0 0 NMOS
M2 2 5 0 0 NMOS

* End of Netlist
