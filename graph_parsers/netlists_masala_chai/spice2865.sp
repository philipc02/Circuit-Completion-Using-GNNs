plaintext
* Transistor Definitions
MREF 2 4 3 3 PMOS
M1 5 2 6 6 NMOS

* Current Source
IREF 4 2 DC 1mA

* Capacitor
CB 2 3 10pF

* Voltage Source
VDD 4 0 DC 5V

* End of Netlist
.END
