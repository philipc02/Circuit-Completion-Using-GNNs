spice
* SPICE Netlist for the given circuit

VCC 5 3 DC VCC
RB 4 2 RB
RC 5 5 RC
RE 6 3 RE
Q1 5 2 6 QNPN

* Model for NPN transistor
.model QNPN NPN
