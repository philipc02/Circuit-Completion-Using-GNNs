plaintext
* SPICE Netlist
VCC 1 0 DC <VCC_value>
VBB 3 5 DC <VBB_value>
RC 1 4 <RC_value>
RE 6 0 <RE_value>
Q1 4 3 6 NPN
