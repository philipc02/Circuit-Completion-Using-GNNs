spice
* SPICE Netlist
R1 3 7 20k
RL 6 8

Q1 5 3 4 NPN
Q2 6 4 2 NPN
Q3 3 10 2 NPN

VCC 7 9 DC VCC
VEE 9 2 DC VEE
VIN 10 9 DC VIN

* Specify additional simulation commands and parameters as needed
.END
