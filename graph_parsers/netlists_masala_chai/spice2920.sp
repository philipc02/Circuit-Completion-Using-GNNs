plaintext
*MOSFET
M1 4 3 2 2 NMOS

*Current Sources
I1 4 6 DC 1mA
I2 2 0 DC 1mA

*Voltage Source
V1 2 0 DC Vin

*Capacitors
C1 6 3 1u
C2 3 0 1u

*.MODEL NMOS
