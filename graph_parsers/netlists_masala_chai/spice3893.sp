plaintext
* SPICE Netlist for the BJT Circuit

VCC 2 0 DC 5V
VEE 3 0 DC -5V
RB 5 0 250k
RC 2 4 1.5k
Q1 2 5 4 NPN

.END
