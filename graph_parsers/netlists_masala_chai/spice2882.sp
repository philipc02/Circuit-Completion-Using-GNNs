spice
* SPICE Netlist

*** Voltage Sources ***
VDD 1 0 DC VDD
Vn3_2_left 2 10 DC Vn3/2
Vn3_2_right 3 7 DC Vn3/2

*** MOSFETs ***
M1 5 9 6 6 NMOS_MODEL
M2 4 5 6 6 NMOS_MODEL
M3 2 10 1 1 PMOS_MODEL
M4 2 3 1 1 PMOS_MODEL

*** End of Netlist ***
