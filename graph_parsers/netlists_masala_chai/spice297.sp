plaintext
* SPICE netlist for given schematic

V_ic 7 10 DC 0
V_oc 8 4 DC 0

R_S 7 2 R_S_value
r_x 2 1 r_x_value
r_in 2 3 r_in_value
2R_T 3 3 2R_T_value
R_L 4 8 R_L_value

C_f 1 4 C_f_value
C_in 2 3 C_in_value
CT_half 3 3 CT_half_value

G_m_V1 6 3 6 5 gm_value

.END
