spice
* Example SPICE Netlist
Vi 3 7 DC

L1 3 2 1uH
C1 2 2 1uF

L2 2 8 1uH
C2 6 8 1uF

R 4 5 1k

* Ground Node
Vgnd 7 0 DC 0
