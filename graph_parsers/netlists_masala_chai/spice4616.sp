plaintext
* Example Circuit
VTH 2 5 DC 5
RTH 2 3 10k

* Node assignments:
* 2: Junction of VTH, RTH, and node A
* 3: Node A
* 5: Node B (ground)

.END
