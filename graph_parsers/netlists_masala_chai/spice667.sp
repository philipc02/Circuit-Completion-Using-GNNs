plaintext
* SPICE netlist for the given circuit
Vx 6 7 DC 0
Ix 6 3 DC 0
R1 3 4 1k
R2 5 2 1k
D1 5 2 D
Vb 4 2 DC 0
.model D D
.end
