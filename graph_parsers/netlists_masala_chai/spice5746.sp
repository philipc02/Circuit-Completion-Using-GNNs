plaintext
* NPN BJT Amplifier Circuit

V1 1 0 DC 10
V2 2 0 DC 4

Q1 4 2 3 NPN

RC 1 4 4.7k
RE 3 0 3.3k

.model NPN NPN
