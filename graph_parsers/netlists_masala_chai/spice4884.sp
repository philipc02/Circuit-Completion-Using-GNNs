* SPICE Netlist for the given schematic

VCC 4 0 DC 20V
Vg 7 0 AC

RG 7 1 50
R1 3 4 100
R2 1 0 200
RE 2 0 30
RL 5 0 10

Q1 3 1 2 NPN

.END
