plaintext
* SPICE Netlist
M1 6 5 8 8 NMOS
M2 3 4 8 8 NMOS
M3 7 2 6 6 PMOS
M4 3 2 1 1 PMOS
I1 7 2 DC [value of I1]
ISS 8 4 DC [value of ISS]
VDD 1 0 DC [value of VDD]
VIN 5 0 DC [value of VIN]

* Additional control statements and analysis commands can go here
.END
