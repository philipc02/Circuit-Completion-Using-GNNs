spice
* Voltage Sources
VCC 3 0 DC 15
VEE 0 0 DC -15
VIN 1 0 DC 0

* Operational Amplifier
XU1 2 0 4 3 0 OPAMP

* Diode
D1 4 0 D1MODEL

* Resistor
RL 4 0 1k

* Diode Model
.model D1MODEL D

.end
