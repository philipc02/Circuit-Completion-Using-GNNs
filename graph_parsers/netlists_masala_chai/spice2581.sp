spice
* SPICE Netlist
VDD 3 0 DC 5V
VT 4 2 DC 1V
RD2 3 2 10k
RT 6 4 5k
M2 2 6 2 2 NMOS_MODEL
.end
