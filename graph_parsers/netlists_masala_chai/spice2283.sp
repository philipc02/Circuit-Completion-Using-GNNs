spice
* SPICE Netlist
V1 5 0 DC 0
R1 5 3 1k
R2 3 2 2k
R3 2 0 2k
R4 2 4 3k
