spice
* PMOS Transistors
M1 3 1 3 3 PMOS L=4u W=?
M2 3 2 3 3 PMOS L=4u W=?
M3 3 6 3 3 PMOS L=4u W=?
M4 3 7 3 3 PMOS L=4u W=?

* NMOS Transistors
M5 3 2 2 2 NMOS L=4u W=?
M6 3 6 6 6 NMOS L=4u W=?
M7 3 5 5 5 NMOS L=4u W=?
M8 3 7 7 7 NMOS L=4u W=?

* Voltage Source
VDD 1 0 DC VDD

* Output
Rout 3 4 1k  ; assumed output load

* GND
VSS 0

* End of Netlist
