V1 5 0 DC 0
Ri 5 0 0
ro 5 3 ro_value
GmV1 4 5 0 Gm
R 4 3 R_value
RL 3 2 RL_value
