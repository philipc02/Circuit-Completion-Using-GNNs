spice
* SPICE Netlist for the Circuit

* Voltage Source
V1 9 0 DC Vs

* Current Source
I1 6 0 DC IEE

* Resistors
R1 8 9 RS
R2 5 4 RS

* Transistors
Q1 3 8 6 NPN
Q2 2 5 6 NPN

* Ground
V2 0 GND DC 0

.end
