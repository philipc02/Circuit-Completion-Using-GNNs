spice
* Q1 is a PNP transistor
Q1 1 2 3 PNP

* Q2 is an NPN transistor
Q2 2 3 4 NPN

* Model definitions for PNP and NPN transistors
.model PNP PNP
.model NPN NPN

* The net numbers are based on the annotated image
