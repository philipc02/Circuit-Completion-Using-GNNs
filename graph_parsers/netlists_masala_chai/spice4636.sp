* SPICE Netlist
VS 8 2 DC 36V
R1 8 1 6k
R2 2 6 3k
RL 6 7 1k
D1 2 4 DMODEL

.model DMODEL D
.end
