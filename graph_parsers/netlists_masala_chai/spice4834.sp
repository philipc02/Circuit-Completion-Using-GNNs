spice
* NPN BJT Amplifier Circuit
* Transistor
Q1 3 2 5 NPN

* Resistors
R1 4 6 1.5k
R2 2 4 330
RC 3 6 1.2k
RL 3 7 6.8k
RE 5 2 470

* Capacitors
C1 4 2
C2 6 3
C3 3 7
C4 5 0

* Voltage Sources
VCC 6 0 DC 15V
Vin 4 0 AC 2mV

* Model for BJT
.model NPN NPN

.end
