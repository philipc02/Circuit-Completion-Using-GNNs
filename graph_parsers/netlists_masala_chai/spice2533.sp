plaintext
* Transistor M1 (NMOS)
M1 4 2 0 0 NMOS

* Transistor M2 (PMOS)
M2 4 3 3 3 PMOS

* Resistor RD
RD 3 4  RD_VALUE

* Voltage Source VDD
VDD 3 0 DC VDD_VALUE

* Voltage Source Vin
Vin 3 3 DC Vin_VALUE

* Voltage Source Vb
Vb 2 0 DC Vb_VALUE

* Simulation commands
.END
