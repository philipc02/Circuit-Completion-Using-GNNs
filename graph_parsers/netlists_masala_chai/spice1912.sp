spice
* SPICE netlist for the provided circuit

* Capacitors
C1 6 1 C1_value
C2 1 4 C2_value
C3 4 3 C3_value

* Resistors
R1 1 2 R1_value
R2 4 2 R2_value
R4 5 3 R4_value
RF 3 3 RF_value

* Op-Amp (Voltage Controlled Voltage Source)
E1 3 5 3 2 -A0_value

* Ground
V0 2 0 DC 0

* End of netlist
