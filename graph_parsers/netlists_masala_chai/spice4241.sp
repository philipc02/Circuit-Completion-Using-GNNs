spice
* MOSFET Definitions
M1 2 2 7 7 NMOS
M2 4 2 7 7 NMOS
M3 5 6 4 4 PMOS

* Current Source
IREF 6 7 DC 1

* Voltage Nodes
VPLUS 6 0 DC V+
VOUT 5 3 IO

* End of Netlist
.end
