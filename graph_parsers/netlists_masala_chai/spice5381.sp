spice
* Capacitor Network
C1 8 10 0.01uF
C2 10 9 0.022uF
C3 9 5 0.01uF
C4 5 3 0.047uF
C5 3 2 0.022uF
C6 2 6 0.022uF
