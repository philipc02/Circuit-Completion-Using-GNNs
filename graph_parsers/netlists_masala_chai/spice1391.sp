spice
* Current Mirror Circuit

* Current Source
IREF 2 0 DC

* BJTs
QREF 4 2 3 QNPN
Q1 0 4 3 QNPN

* Model Definition
.model QNPN NPN

* Net Definitions
VCC 4 0 DC
AE 2 0
NAE 0 3
