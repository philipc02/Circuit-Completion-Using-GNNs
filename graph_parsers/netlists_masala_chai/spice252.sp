spice
* SPICE netlist

VCC 1 0 DC VCC
VBias1 3 0 DC VBias1
VBiasCM 5 0 DC VBiasCM

Q1 2 2 7 npn
Q2 2 2 1 npn
Q3 3 4 1 npn
Q4 4 5 1 npn
Q5 1 2 2 npn
Q6 3 3 1 npn
Q7 3 3 1 npn

R3 2 5 R3_value
R4 5 5 R4_value
R5 1 6 R5_value
R6 3 6 R6_value
R7 3 3 R7_value

.end
