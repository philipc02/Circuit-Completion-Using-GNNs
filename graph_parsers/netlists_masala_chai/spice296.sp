plaintext
* Components
V1 5 0 DC <value_of_vic> AC 1
RS 5 4 <value_of_RS>
RL 3 6 <value_of_RL>
RT 2 0 <value_of_2RT>
CT 2 0 <value_of_CT/2>

* MOSFET
M1 3 4 2 2 NMOS

* Netlist info
* Node 0 is the ground node
