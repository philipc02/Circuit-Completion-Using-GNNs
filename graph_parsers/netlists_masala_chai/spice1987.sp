* RC Circuit
R1 Vin Vout  R1_value
C1 Vout 0    C1_value
Vin Vin 0    DC Vin_value
