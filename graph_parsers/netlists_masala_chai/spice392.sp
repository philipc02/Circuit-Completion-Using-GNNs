spice
* SPICE Netlist
Iin 4 3 DC <value>
Rpi 5 3 rpi_value
RF 6 2 RF_value
Vout 2 0 DC 0
* End of Netlist
