spice
* SPICE Netlist
V1 2 4 DC
R1 2 3 1k
C1 3 4 1p
.END
