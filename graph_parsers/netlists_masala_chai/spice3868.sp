* SPICE Netlist for Given Circuit

VTH 2 1 DC <Voltage Value>
V+ 5 0 DC 9
V- 3 0 DC -9

RTH 2 4 <RTH Value>
RE 5 4 <RE Value>
RC 4 3 <RC Value>

* NPN Transistor
Q1 5 2 4 QNPN

.model QNPN NPN
