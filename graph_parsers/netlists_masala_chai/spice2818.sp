plaintext
*MOSFET Transistors
M1 4 6 0 0 NMOS
M2 4 3 0 0 NMOS
M3 4 2 2 2 PMOS

*Capacitors
C1 4 3 <value_C1>
C2 2 <node_for_C2> <value_C2>

*Resistors
R1 Vb 3 <value_R1>
R2 2 4 <value_R2>

*Voltage Sources
VDD 2 0 <value_VDD>
Vin 6 0 <value_Vin>
Vb Vb 0 <value_Vb>

*Output
Vout 4
