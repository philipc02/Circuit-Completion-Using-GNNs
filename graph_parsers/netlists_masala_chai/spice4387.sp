plaintext
* SPICE Netlist for the given circuit

* Transistors
Q1 7 8 6 NPN
Q2 2 7 5 NPN
Q3 4 2 3 NPN

* Current Sources
I1 8 6 DC 0.5m
I2 3 4 DC 1m

* Resistors
R1 2 V+ 50k
R2 3 4 5k

* Voltage definitions
V+ V+ 0 DC <Voltage_Value>
Vin 8 0 DC <Input_Voltage_Value>

* End of Netlist
