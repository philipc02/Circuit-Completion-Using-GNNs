plaintext
* NMOS Amplifier Circuit

V1 5 0 DC 15V
R1 5 1 1.8k
M1 1 2 0 0 BS107
V2 2 0 DC VGS

.model BS107 NMOS (LEVEL=1)

.END
