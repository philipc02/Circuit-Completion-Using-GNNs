spice
* SPICE Netlist

Vin 6 4 DC 0V
D1 6 2 Dbreak
R1 2 4 1k
Vout 2 4

.model Dbreak D
