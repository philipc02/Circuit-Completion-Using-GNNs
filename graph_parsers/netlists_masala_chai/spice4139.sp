spice
* SPICE Netlist
Vi 6 8 DC 0
RS 6 10 200
CC1 10 2 1u
Rpi 2 5 1k
Cpi 2 5 1u
Gm 4 3 VCVS 2 5 0.01
Cmu 2 3 1u
RC1 4 3 500
RL 3 7 1k
CC2 3 9 1u
*.end
