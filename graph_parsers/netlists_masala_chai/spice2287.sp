spice
* SPICE Netlist
Vin in 0 DC 0V
L1 in out 1uH
R1 out mid 1k
C1 mid 0 1uF
