spice
* NMOS Amplifier Circuit
M1 vout vin 1 1 NMOS L=1u W=1u
RD vout 2 RD_value
RS 1 0 RS_value
VDD 2 0 VDD_value
* End of Netlist
