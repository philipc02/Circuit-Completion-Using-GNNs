spice
* SPICE netlist for the schematic
R1 5 4 R1_value
R2 7 3 R2_value
R3 2 7 R3_value
C1 3 8 C_value
V1 66 5 vi

* Define .END to terminate the netlist
.END
