spice
* SPICE Netlist
V1 3 4 DC 0
R1 3 2 R1_value
C1 2 4 C1_value
