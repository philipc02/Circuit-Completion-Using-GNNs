spice
* SPICE Netlist

Vin 2 1 DC 0
Rs 2 3 1000
I1 3 1 DC 0
G1 3 1 POLY(1) (2,3) 0 0 1/gm

* End of Netlist
