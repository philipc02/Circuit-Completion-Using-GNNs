spice
* SPICE Netlist
* Components
V1 6 3 DC 10V
V2 8 3 DC 10V
Vs 6 3 AC 1V

* Resistors
Re 2 3 10k
Rc 4 8 5k
Rl 4 7 10k

* Capacitors
C1 6 2 4.7uF
C2 4 7 4.7uF

* End of Netlist
