spice
* Netlist for the given Circuit

V1 7 0 DC 0
Vplus 4 0 DC 10
Vminus 3 0 DC -10
C1 6 4 1u
C2 3 2 1u
Vs 6 7 DC
RE 4 0 10k
RC 2 3 5k
RL 3 0 50k
Q1 4 6 3 NPN

.MODEL NPN NPN

.END
