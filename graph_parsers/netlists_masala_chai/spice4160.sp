spice
* NPN Transistor
Q1 4 1 2 QNPN

* Current Source
I1 4 22 DC I_O

* Resistor
RL 4 3 RL

* Voltage Sources
V+ 1 0 DC V+
V- 22 0 DC V-

* Connections
* VO node is 4
* Ground node is 3
