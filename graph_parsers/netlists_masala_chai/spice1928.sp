spice
* NMOS Differential Pair Circuit

VDD 5 0 DC VDD

RD1 5 4 RD
RD2 5 2 RD

M1 4 6 2 2 NMOS
M2 2 3 2 2 NMOS

ISS 2 0 DC ISS

* Models
.model NMOS NMOS

.end
