* Netlist for the circuit
   R1 2 4 1k
   D1 4 3 D1_model
   .model D1_model D
   .end
