* NPN Transistor Circuit
V1 5 0 DC 10
RC 5 3 4.7k
RE 3 4 3.3k
Q1 3 2 4 NPN
