spice
* Differential Pair Amplifier
VDD 9 0 DC 5V
VSS 0 5 DC -5V

* PMOS Transistors
M3 8 2 7 7 PMOS L=1u W=10u
M4 4 2 7 7 PMOS L=1u W=10u

* NMOS Transistors
M1 8 6 5 5 NMOS L=1u W=10u
M2 4 4 5 5 NMOS L=1u W=10u

* Connections
VBIAS 2 0 DC 1V
Vi1 6 0
Vi2 4 0
Vo1 8 0
Vo2 4 0

.END
