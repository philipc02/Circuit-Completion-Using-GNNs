spice
* SPICE Netlist for the circuit

* Voltage Source
V1 3 2 DC Vin

* Current Source
Iin 5 2 DC Iin

* Inductor
L1 4 3 L1_value

* Resistor
R1 4 2 R1_value

* Capacitor
C1 3 2 C1_value

* End of Netlist
