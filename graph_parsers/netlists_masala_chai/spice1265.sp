spice
* NMOS Common Source Amplifier

* NMOS Transistor
M1 2 3 4 4 NMOS

* Resistor
RS 4 0 500

* Voltage Source
VDD 2 0 DC 1.8

* Input Signal (Optional, assuming Vin)
VIN 3 0 DC 0

* Model (Specification needed for simulation)
.model NMOS NMOS(Level=1)

.end
