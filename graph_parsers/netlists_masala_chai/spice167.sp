plaintext
* SPICE Netlist
Q1 3 2 2 NPN
Q2 5 4 44 NPN
I1 5 3 DC
I2 5 4 DC
VDD 5 0 DC
