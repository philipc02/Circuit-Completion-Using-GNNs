spice
* NMOS Amplifier Circuit
M1 3 5 2 2 NMOS L=1u W=1u
RD 3 7 560
RG 5 0 10MEG
VDD 8 0 DC 18
VDS 4 2 DC 0
