V1 5 4 DC 0V   ; Voltage Source Vi(s)
   RS 5 2 1k      ; Resistor RS
   CS 2 2 1uF     ; Capacitor CS
   RP 2 3 1k      ; Resistor RP
   .end
