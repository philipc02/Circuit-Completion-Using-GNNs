spice
* NMOS Amplifier Circuit

Vsig 7 0 DC
Rsig 7 2  R_sig
Rs 2 0 R_S
Rd 3 0 R_D
M1 3 2 0 0 NMOS

.model NMOS NMOS level=1

.end
