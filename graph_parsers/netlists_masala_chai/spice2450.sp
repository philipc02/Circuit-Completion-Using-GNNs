plaintext
* SPICE netlist for the schematic

M1 6 3 5 5 NMOS
C1 2 5 <value_C1>
C2 5 6 <value_C2>
V1 5 2 DC 3
V2 6 5 DC 3
Vin 3 4 <value_Vin>
