spice
* SPICE Netlist
V1 7 0 DC 2
RS 7 5 1k
RE 8 0 1k
RL 4 6 1k
Q1 5 5 8 NPN
Q3 3 4 6 NPN
