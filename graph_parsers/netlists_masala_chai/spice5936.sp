plaintext
* SPICE Netlist for the given schematic

M1 5 2 5 5 NMOS
M2 5 3 5 5 NMOS
M3 6 4 6 6 PMOS
IREF 5 1 DC

VOUT 6 0 DC 0
