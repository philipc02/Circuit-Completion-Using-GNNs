spice
* SPICE Netlist

VPLUS 5 0 DC 5V
VMINUS 0 1 DC -5V

IREF 1 2 DC 10uA

M1 2 4 10 10 NMOS
M2 22 2 10 10 NMOS
M3 5 2 2 2 PMOS
M4 22 2 2 2 PMOS
M5 3 3 22 22 PMOS
M6 6 3 3 3 PMOS
M7 0 3 3 3 NMOS
M10 1 2 0 0 NMOS
M11 10 4 4 4 NMOS

.model NMOS NMOS (LEVEL=1)
.model PMOS PMOS (LEVEL=1)

.END
