* Simple BJT Amplifier

Q1 Vout Vin 0 NPN
RC Vout VCC 1k
Vin Vin 0 DC 0V
VCC VCC 0 DC 15V

.model NPN NPN (Is=1e-14 Vaf=100 Bf=100)
