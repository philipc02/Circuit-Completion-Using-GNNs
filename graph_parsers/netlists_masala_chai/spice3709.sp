spice
* SPICE Netlist

M1 2 4 5 5 NMOS
V1 2 3 DC 2
V2 5 0 DC 1

* Node 0 is the ground reference.
