* NMOS Transistor
M1 3 4 2 2 NMOS

* Voltage Source
V1 3 2 DC 5

* Current Source
I1 3 6 DC 1m

* Ground
V0 2 0 DC 0

* Model
.model NMOS NMOS (LEVEL=1)

.ends
