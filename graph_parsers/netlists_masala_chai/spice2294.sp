* SPICE Netlist for the given schematic
R1 4 5 1k
D1 4 2 D
V1 Vin 4 DC 0
.ends
