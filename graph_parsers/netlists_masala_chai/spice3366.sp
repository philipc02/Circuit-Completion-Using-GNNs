spice
* SPICE netlist generated for the schematic

* Current Source
I1 3 2 g_m*V(6,5)

* Resistor
R1 4 5 r_e

* Node Definitions
* Node 1: e (connected to net 4)
* Node 2: emitter of current source (connected to net 2)
* Node 3: c (connected to net 3)
* Node 4: One terminal of resistor (connected to net 4)
* Node 5: Other terminal of resistor (connected to net 5)
* Node 6: Base (connected to net 6)

.end
