* Netlist for the given schematic
I1 3 2 DC 0.1
D1 5 4 Dmodel
D2 4 2 Dmodel
V1 3 2 DC 5.0

.model Dmodel D
