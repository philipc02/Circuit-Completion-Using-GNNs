spice
* Transistor
Q1 5 2 3 BJT_NPN

* Resistors
R1 4 5 10k
R2 2 8 2.2k
RC 5 6 3.6k
RE 3 8 1k
RL 5 1 100k

* Capacitors
C1 4 5 0.1u
C2 5 1 0.1u
C3 3 8 0.1u

* Voltage Sources
VCC 6 8 DC 10V
Vac 4 8 AC 1V

* Models
.model BJT_NPN NPN
