plaintext
* SPICE Netlist

Vsig 4 3 DC

Rsig 4 2 1k

M1 5 2 3 3 NMOS

RD 5 3 1k

* End of Netlist
