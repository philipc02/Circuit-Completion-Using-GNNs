plaintext
* SPICE Netlist

M1 2 4 5 5 NMOS
M2 2 Vin 5 5 NMOS
M3 2 3 6 6 PMOS

* Voltage Sources
VDD 6 0 DC <value>

* Bias Voltages
Vb1 3 0 DC <value>
Vb2 4 0 DC <value>
Vin Vin 0 DC <value>

* End of Netlist
