spice
* Netlist for the given circuit
* Components
C1 1 5 C_value
D1 2 5 D_model
R1 6 2 R_value
* Nodes
* 1: vi, 2: Ground, 5: Node connecting diode and capacitor, 6: vo

* Voltage source
V1 1 0 V_input

* End of netlist
