spice
* BJT Circuit
Q1 2 6 3 NPN

* Voltage Sources
V_BE 6 3 DC
V_CE 4 3 DC

* Ground
V_GND 3 0 DC 0

.END
