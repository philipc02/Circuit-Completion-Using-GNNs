spice
* NMOS Amplifier Circuit

VDD 4 0 DC 30V
RD 4 3 2k
RG 2 0 1Meg
RS 3 6 400
M1 3 2 6 6 NMOS

.model NMOS NMOS

.end
