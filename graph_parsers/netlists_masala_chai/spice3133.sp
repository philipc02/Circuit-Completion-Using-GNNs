* SPICE Netlist
VDD 7 0 DC 7V
I1 2 7 DC 25uA

M13 2 0 6 6 NMOS L=40n W=8u
M14 2 0 4 4 NMOS L=40n W=8u
M12 6 0 0 0 NMOS L=40n W=8u
M1 3 5 4 4 PMOS L=40n W=300u
M2 3 5 4 4 PMOS L=40n W=300u
M11 4 1 0 0 NMOS L=40n W=600u
