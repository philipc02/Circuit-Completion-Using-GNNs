plaintext
* Op-Amp circuit
* Components

* Voltage Input
Vin 2 0 DC 0

* Op-Amp
* Assuming ideal op-amp for the netlist
A1 2 0 2 opamp

* Resistors
R1 2 4 1k
R2 4 0 1k

* End of netlist
