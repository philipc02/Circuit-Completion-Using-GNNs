spice
* SPICE Netlist for the given circuit

M1 2 1 0 0 NMOS
Ix 1 2 DC 1mA
C1 2 0 1uF

.model NMOS NMOS
