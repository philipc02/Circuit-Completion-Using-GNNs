plaintext
* SPICE Netlist
M1 4 in 2 2 NMOS
M2 3 6 vdd vdd NMOS

Rx 5 vdd Rx
Rout 3 3 Rout

Vin in 0 DC 0
Vdd vdd 0 DC 5

* Other necessary model definitions and simulations here.
.END
