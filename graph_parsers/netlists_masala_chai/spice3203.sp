* SPICE Netlist

M1 7 7 7 NMOS
M2 2 3 7 NMOS
M3 1 2 6 PMOS
M4 6 1 6 PMOS
M5 4 3 2 NMOS
M6 5 4 4 NMOS

Ra 6 5 1k   ; Resistance value is assumed for illustration
Rb 5 4 1k   ; Resistance value is assumed for illustration
Rs 7 0 1k   ; Resistance value is assumed for illustration

VDD 6 0 DC 5V ; Example DC power supply

* End of Netlist
