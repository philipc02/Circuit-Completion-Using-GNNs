plaintext
I1 0 2 DC 1A
RN 2 1 1k
RL 1 3 1k
.END
