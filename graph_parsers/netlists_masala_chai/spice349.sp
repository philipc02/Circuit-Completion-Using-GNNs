plaintext
* Basic Amplifier and Feedback Network

Vi 3 8 DC 0
G1 2 3 Value = {-V(1,3)}
Rf 2 5 1k
Zf 2 3 1k
Rl 5 6 1k
Ii 4 8 DC 0

.END
