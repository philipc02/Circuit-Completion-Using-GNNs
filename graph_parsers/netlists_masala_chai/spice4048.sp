spice
* SPICE Netlist

V1 6 0
RS 6 2 0.1k
CC 2 0 10u
R1_R2 2 0 5k
G1 2 4 VALUE={gm*V(2,0)}
RE 4 0 0.5k
RC 4 3 5k
RL 3 5 10k
CL 5 0 15p
