plaintext
* SPICE netlist generated from schematic

Vin 5 2 DC 0
Rs 5 3 1k
Igm1 4 3 DC 1
Igm2 3 2 DC 1

Vx 4 2 DC 0

* Voltage source Vx is assumed as ground reference
