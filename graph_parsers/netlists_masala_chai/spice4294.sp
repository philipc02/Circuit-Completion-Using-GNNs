V1 Vin 0 DC 0
I2 5 0 DC I2
IREF 3 0 DC IREF

* Transistor connections: (Collector, Base, Emitter)
Q1 4 2 3 NPN
Q2 5 2 3 NPN
Q0 3 6 0 NPN

* Resistors
RE1 5 4 RE
RE2 4 5 RE
RL 3 0 RL
R1 3 0 R1

* Voltage source
V+ Vplus 0 DC V+

* Connecting nodes to nets
Vin 6 0 0
