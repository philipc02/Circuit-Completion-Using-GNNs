plaintext
* SPICE Netlist

V1 1 0 DC 6V
V2 5 0 DC 10V

R1 5 6 4.7k
R2 3 0 3.3k

Q1 6 2 3 NPN

* End of Netlist
