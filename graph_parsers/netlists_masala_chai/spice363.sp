spice
* SPICE Netlist for Amplifier Circuit

* Voltage Source
V1 9 2 Vi

* Current Source
I1 0 9 0.0 ; i1 - Assuming some value or will be defined in simulation

* Voltage Source from Feedback Network
V2 7 2 h12Vc

* Current Source in Amplifier
I2 2 8 h21fi

* Resistors
R1 9 2 h11
R2 2 0 h11f
R3 8 2 h22a
R4 5 2 h22b
R5 5 2 h22

* Nodes
* Node 0 is Ground
* Node 2 is connected to the common reference for resistor and amplifier outputs
* Node 3, 4, 5 are for new feedback network connections
* Node 7 is feedback network voltage source
* Node 8 is amplifier block's current source h21fi

.end
