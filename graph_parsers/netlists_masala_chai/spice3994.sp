spice
* BJT Amplifier Circuit

* Voltage Sources
Vs 1 0 DC 0V
Vplus 7 0 DC 5V
Vminus 5 0 DC -5V

* Resistors
R1 4 1 1k
R2 1 5 1k
RC 7 3 1.2k
RE 6 5 0.2k

* Capacitor
CC 1 2 1u

* BJT Transistor
Q1 3 2 6 NPN

* Output
VO 3 0

.end
