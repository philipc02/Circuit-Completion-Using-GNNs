spice
* SPICE Netlist

* Current Source
ISS 9 3 DC 0

* NMOS Transistors
M9 1 2 3 3 NMOS
M10 3 4 2 2 NMOS
M11 5 6 1 1 NMOS
M12 5 6 1 1 NMOS

* PMOS Transistors
M7 3 8 9 9 PMOS
M2 2 3 8 8 PMOS
M4 7 3 9 9 PMOS
M8 8 7 9 9 PMOS
M5 5 4 9 9 PMOS
M1 1 5 9 9 PMOS
M3 6 5 9 9 PMOS
M6 6 5 9 9 PMOS

* Capacitors
CL 4 0 1uF
CL 5 0 1uF

* End of Netlist
