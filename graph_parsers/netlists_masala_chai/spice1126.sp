spice
   * PMOS Transistor and Voltage Sources

   M1 3 2 5 5 PMOS

   V1 2 0 DC 2V
   V2 5 0 DC 2V

   .model PMOS PMOS
   .end
