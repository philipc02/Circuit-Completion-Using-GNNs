spice
* SPICE Netlist
VS 5 7 DC 5V
R1 5 3 1k
R2 3 4 2.2k
R3 4 2 4.7k
R4 2 7 10k
.END
