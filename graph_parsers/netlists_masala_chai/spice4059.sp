spice
Is 10 4 DC <current_value>
Cc1 10 3 <value>
Cc2 5 8 <value>
Ce 9 2 <value>
Rs 4 3 <value>
R1 6 6 <value> ; (connected to the same net as Vcc)
R2 3 12 <value>
Rc 8 6 <value>
Re 9 2 <value>
Rl 5 4 <value>
Q1 8 3 9 QNPN ; NPN transistor (Collector=8, Base=3, Emitter=9)
Vcc 6 0 DC <voltage_value>
