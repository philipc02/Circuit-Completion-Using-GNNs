plaintext
* PMOS and NMOS Inverter Circuit

VDD 1 2 DC VDD

* PMOS Transistor
MP QP 3 4 1 1 PMOS_MODEL

* NMOS Transistor
MN QN 3 4 5 5 NMOS_MODEL

* Input Voltage
VI 4 0 DC 0V

* Voltage Source Reference
VSS 5 0 DC 0V

.END
