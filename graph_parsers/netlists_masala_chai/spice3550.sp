plaintext
* SPICE netlist
* Voltage Source
V1 6 3 Vi

* Resistors
RS 6 7 RS
RX 7 9 r_x
Rxi 9 4 Rxi
RK 4 5 r_k
RL 8 3 RL

* Capacitors
CX 9 5 Cx
CMU 2 3 Cmu

* Current Source
I1 4 2 gmVpi

* End of netlist
