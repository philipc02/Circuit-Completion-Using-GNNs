spice
* Transistor Q1 (NPN)
Q1 3 2 0 NPN

* Transistor Q2 (NPN)
Q2 4 3 4 NPN

* Resistor RC
RC 3 4 1k

* Input Voltage Source
Vin 2 0 DC 0

* Supply Voltage
VCC 4 0 DC 5V

.model NPN NPN
.end
