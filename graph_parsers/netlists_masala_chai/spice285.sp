plaintext
* SPICE Netlist
Vi 3 0 DC 0V
RS 3 6 1k ; Replace 1k with actual resistance value if known
M1 4 6 0 0 NMOS ; NMOS drain=4, gate=6, source=0, body=0
RL 4 5 1k ; Replace 1k with actual resistance value if known
