plaintext
* NPN Transistor Circuit

VCC 3 0 DC 5V
RC 3 2 1k
Q1 3 2 0 NPN

.model NPN NPN
