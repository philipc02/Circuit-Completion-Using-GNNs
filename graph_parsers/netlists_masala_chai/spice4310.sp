spice
* List of Components
* Transistors
M1 2 5 3 3 NMOS
M2 2 9 2 2 NMOS

* Resistors
RD1 4 2 RD
RD2 4 2 RD

* Current Source
I1 8 2 DC I_Q

* Voltage Sources
V1 5 0 DC V_G1
V2 9 0 DC V_G2

* Voltage Supply
V3 4 0 DC V+
V4 2 8 DC V-

* End of netlist
