plaintext
* SPICE Netlist for the given circuit

I1 1 2 DC Ii
Vfb 4 0 DC Vfb

Rif 1 2 Rif
Ri 2 3 Ri
Ro 3 3 Ro
Rof 3 4 Rof
R2 3 2 R2
R1 2 0 R1

E1 3 2 2 3 Av

.end
