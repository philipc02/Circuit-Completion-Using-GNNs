* SPICE netlist for the given circuit

* Voltage Source
V1 1 0 DC 10V

* Resistors
R1 1 2 100k
R2 2 3 Rtransducer

* Operational Amplifier
* Assuming a generic op-amp model (name it as needed)
XOP 2 0 3 OPAMP_MODEL

* Input Current Source (optional for showing connection)
Iin 2 0 DC 0

* Output (add a load if necessary)
* Rload 3 0 1k (Example load resistor)

.END
