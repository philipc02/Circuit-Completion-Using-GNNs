spice
* Transistors
Q3 4 7 2 NPN
Q4 5 4 3 NPN
Q5 3 2 8 NPN

* Diodes
D1 7 2 D
D2 2 2 D

* Current Source
ILS 2 2 DC VALUE

* Resistors
RE 4 7 1k
RL 3 6 10k

* Voltage Sources
VCC 4 0 DC VALUE
VEE 2 0 DC VALUE

* Output
VOUT 3 0 DC VALUE

.end
