spice
* SPICE netlist for the given circuit

M1 3 4 2 2 PMOS
M2 3 2 5 5 NMOS
CH 3 5 CH_VALUE

* Voltage and ground connections
VCK 4 0 DC CK_VALUE
VSS 5 0 DC 0
