spice
* SPICE Netlist
Vin 1 2 DC 15V
R1 2 3 100k
R2 2 4 10k
* Ideal op-amp model
Eopamp 2 0 3 2 1e6
V1 3 0 DC 15V
V2 2 0 DC 0V
