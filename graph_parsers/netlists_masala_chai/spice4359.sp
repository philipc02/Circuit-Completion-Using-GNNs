spice
* NMOS Transistors
M1 2 5 4 4 NMOS
M2 2 3 3 3 NMOS

* Current Source
I1 4 8 DC IQ

* Resistors
R1 6 2 RD
R2 3 2 RD

* Voltage Sources
Vplus 2 0 DC V+
Vcm 5 0 DC Vcm
Vminus 8 0 DC V-
VD2 3 0

* End of Netlist
