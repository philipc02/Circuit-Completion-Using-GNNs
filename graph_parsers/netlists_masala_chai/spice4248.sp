plaintext
* SPICE netlist for the given circuit

VCC 8 2 DC VCC
V1 6 4 DC Vi

R1 2 7 R1
RC 2 3 RC
R2 7 4 R2

CC 6 7 CC

Q1 3 7 4 NPN

.model NPN NPN
