spice
* SPICE Netlist for the given schematic

* NMOS Transistors
M1 7 6 8 8 NMOS
M2 9 10 8 8 NMOS

* PMOS Transistors
M3 3 6 8 8 PMOS
M4 2 9 8 8 PMOS

* Current Source
I1 5 12 DC 0

* Resistor
R1 3 8 r_o3

* Voltage Source
V1 2 8 DC VDD

* End of Netlist
