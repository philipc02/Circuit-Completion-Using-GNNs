spice
* Transistor Definitions
M1 4 4 5 5 NMOS L=150n W=22.5u
M2 8 7 9 9 NMOS L=150n W=5.6u
M3 5 2 2 2 PMOS L=160n W=6.3u
M4 9 2 2 2 PMOS L=160n W=6.3u
M5 5 1 1 1 PMOS L=160n W=6.3u
M6 3 3 2 2 PMOS L=160n W=6.3u
M7 2 2 12 12 NMOS L=160n W=6.3u
M8 2 11 12 12 NMOS L=160n W=6.3u
M9 6 6 2 2 NMOS L=80n W=5.1u
M10 9 2 10 10 NMOS L=80n W=5.1u
M11 7 6 6 6 NMOS L=160n W=1.25u
M12 10 8 0 0 NMOS L=160n W=1.25u

* Current Sources
I1 2 6 DC 113uA
I2 0 7 DC 2.5uA
I3 12 2 DC 120uA
I4 0 10 DC 1.25uA

* Capacitors
C1 4 2 0.15pF

* Resistors
R1 2 9 9k
R2 8 0 160k

* Voltage Sources
Vdd 12 0 DC Vdd
Vout1 6 0
Vout2 10 0
