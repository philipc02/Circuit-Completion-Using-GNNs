spice
* Netlist for the given circuit

Vin vin 0 DC 0V
R1 vin 5 1k
D1 5 3 Dmodel
D2 3 4 Dmodel
D3 4 0 Dmodel

.model Dmodel D
