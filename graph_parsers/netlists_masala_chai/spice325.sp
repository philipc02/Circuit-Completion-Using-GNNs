spice
* Circuit Description
Vi 8 9 DC 0
RS 8 7 1k
RL 5 6 1k
Q1 4 7 3 NPN
Q2 5 3 2 NPN
C1 4 0 10u

* Connections
VDD 4 0 DC 5V
