VCC 6 0 DC VCC
Vin 7 0

Q1 6 8 4 NPN
Q2 8 2 9 PNP

R1 6 7 R1_Value
R2 7 8 R2_Value
R3 8 2 R3_Value
R4 2 4 R4_Value
RL 5 0 RL_Value

C1 7 2 C1_Value
C2 5 8 C2_Value

.model NPN NPN
.model PNP PNP

.end
