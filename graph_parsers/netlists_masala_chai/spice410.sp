spice
*SPICE Netlist

* Transistors
M1 6 3 5 5 NMOS
M2 6 4 22 22 PMOS

* Current Source
I1 22 6 DC 100uA

* Voltage Source
V1 3 0 DC Vi

* End of Netlist
