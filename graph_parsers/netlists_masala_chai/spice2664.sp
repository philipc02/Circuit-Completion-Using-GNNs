plaintext
* Differential Pair with Current Source
M1 2 1 4 4 NMOS
M2 3 5 4 4 NMOS
M3 2 2 6 6 PMOS
M4 3 2 6 6 PMOS
I1 4 0 DC 1mA
VDD 6 0 DC 5V
Vin1 1 0 DC 0V
Vin2 5 0 DC 0V
Vout 3 0
.tran 1n 100n
.end
