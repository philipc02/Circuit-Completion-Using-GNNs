* SPICE Netlist for the circuit

VTH 4 0 DC 6V
VB 2 0 DC 0V
VEE 3 5 DC -5V

RTH 4 2 2.5k
RB 2 0 10k
RE 3 5 5k

Q1 4 2 3 NPN

.model NPN NPN
