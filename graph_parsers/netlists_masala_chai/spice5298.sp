plaintext
* Netlist for given schematic

R1 4 5 680
R2 7 2 330
R3 6 3 220
I1 6 3 DC 10mA
V1 6 3 DC 0

.END
