plaintext
* SPICE Netlist

V1 6 0 DC v1
V2 4 0 DC v2
V3 5 0 DC v3

R1 6 2 3R
R2 4 2 3R
R3 5 2 3R
R4 2 3 R

XOPAMP 3 2 3 0 OPAMP

* End of netlist
