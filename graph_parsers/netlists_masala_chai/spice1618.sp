spice
   * Transistors
   M3 net2 net2 net1 net1 NMOS
   M4 net4 net3 net2 net2 NMOS

   * Current Sources
   I1 net2 net1 DC
   I2 net3 net2 DC

   * Resistor
   RL net3 net0 1k

   * Voltage Source
   VDD net4 net0 DC

   .end
