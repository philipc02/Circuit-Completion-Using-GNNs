* Differential Amplifier SPICE Netlist

* Voltage Sources
VBG 3 2 DC VALUE

* Current Sources
I1 6 2 DC VALUE
I2 3 5 DC VALUE

* Transistors
Q1 6 2 4 NPN
Q2 4 3 5 NPN

* Resistor
RL 4 0 VALUE

* Simulation Commands
* .DC or .TRAN or .AC for appropriate analyses
