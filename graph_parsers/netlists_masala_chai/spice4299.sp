* SPICE Netlist for the Circuit

* Transistors
Q1 6 5 4 NPN
Q2 3 2 4 NPN

* Current Source
I1 4 0 DC IQ

* Voltage Sources
VBE1 5 0 DC VB1
VBE2 2 0 DC VB2

* Resistors
RC1 3 8 RC
RC2 6 8 RC

* Global Nodes
V+ 8 0
V- 4 0

.end
