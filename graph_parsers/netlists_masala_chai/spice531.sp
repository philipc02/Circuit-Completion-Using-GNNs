spice
* MOSFETs
M5h 6 7 8 8 NMOS
M2 7 2 2 2 NMOS
M6 3 2 2 2 NMOS

* Resistors
r_o7 4 3 r_o7_value
r_o4 2 0 r_o4_value

* Capacitor
C 2 5 C_value

* Voltage Sources
Vmc 6 0 v_mc_value
Vic 7 0 v_ic_value
Voc 3 0 v_oc_value

* Definition of NMOS models (Example)
.model NMOS nmos level=1
