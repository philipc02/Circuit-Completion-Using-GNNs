plaintext
* Example SPICE Netlist
V1 2 0 DC 2
C1 2 3 47u
R1 3 0 10k
.end
