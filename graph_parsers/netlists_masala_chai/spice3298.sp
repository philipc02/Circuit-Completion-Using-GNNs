plaintext
* SPICE Netlist

M1 2 5 6 6 NMOS
I1 3 2 DC 1A
C1 5 0 10uF
C2 2 0 10uF
L1 5 2 10uH
VDD 3 0 DC 5V

* End of netlist
