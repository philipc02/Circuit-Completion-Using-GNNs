spice
* SPICE Netlist for the given schematic

Vin 2 0 DC 0
IB1 2 0 DC 0
IB2 2 0 DC 0

* Ideal Op-Amp
A1 2 2 Vout

R1 Vout 3 1k
R2 2 0 1k

* End of netlist
