* SPICE Netlist for the circuit

VBB 5 3 DC 0.2V
VCC 4 2 DC 2V
RC 3 4 4k
Q1 2 3 1 NPN
.model NPN NPN
