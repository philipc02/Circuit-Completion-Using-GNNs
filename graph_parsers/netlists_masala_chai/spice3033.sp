spice
* SPICE Netlist

* NMOS Transistor M1
M1 4 3 2 2 NMOS

* PMOS Transistor M3
M3 5 6 5 5 PMOS

* NMOS Transistor M5
M5 4 5 7 7 NMOS

* Current Source Iss
I1 2 0 Iss

* Capacitor Ctot
C1 4 0 Ctot

* Voltage Sources for Biasing
Vb1 3 0 DC Vb1
Vb4 7 0 DC Vb4

* Input Voltage
Vin 4 0 DC Vin

* End of Netlist
