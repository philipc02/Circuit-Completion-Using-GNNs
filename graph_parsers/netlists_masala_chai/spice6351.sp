I1 4 7 DC 1
R1 6 2 R
C1 2 9 C
L1 5 3 L
V0 5 3 DC 0
