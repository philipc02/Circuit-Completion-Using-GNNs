spice
* Transistor Definitions
Q38 4 2 8 PNP
Q39 4 2 22 NPN
Q40 3 10 22 NPN
Q41 10 2 22 NPN
Q42 6 2 5 PNP
Q43 6 2 2 PNP
Q44 7 6 44 NPN
Q45 4 22 2 NPN
Q46 22 2 2 NPN
Q47 22 2 2 PNP
Q48 22 2 2 NPN
Q49 22 5 2 NPN

* Current Source Definitions
I1 4 8 DC 7.4u
I2 11 2 DC 18u
I3 2 6 DC 33u
I4 2 2 DC 6u
I5 2 7 DC 6u

* Resistor Definitions
R53 2 3 1.3k
R55 6 9 7.5k
R56 6 44 7.5k
R58 4 3 2.5k
R59 4 5 2.5k
R60 6 2 1.3k

* Voltage Definitions
VCC 3 0 DC 1

* End of netlist
