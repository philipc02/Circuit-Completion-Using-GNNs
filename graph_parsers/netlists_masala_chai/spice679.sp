spice
Iin 3 2 DC 1A
R1 3 2 1k
D1 3 2 Dmodel
Vout 3 2 DC 0V

.model Dmodel D
