* Op-Amp Circuit
V1 Vin 0 DC 0
C1 2 Vin 0.1uF
R1 2 Vout 10k
* Op-amp modeled as controlled source
A0 0 2 Vout Vout Vout
.end
