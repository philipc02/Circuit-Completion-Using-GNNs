spice
* NMOS Transistor
M1 3 3 2 2 NMOS

* Resistances
RO1 3 4 RO1
Gm2_ro2 2 2 VALUE = {(1/gm2) || ro2}

* Current Source
I_Rout 5 3 DC Rout

* Connections
V3 5 4 DC 0
