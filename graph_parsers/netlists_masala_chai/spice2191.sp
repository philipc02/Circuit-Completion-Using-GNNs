spice
*SPICE Netlist

M1 Vout Vin 2 2 NMOS
M2 2 Vb 2 2 NMOS
M3 2 VDD 3 3 PMOS

*.end
