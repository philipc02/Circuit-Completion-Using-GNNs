spice
* SPICE Netlist
RSB 6 0 '<RS + rb>'
RPi1 6 3 r_pi1
RE 3 0 R_E
RL1 2 0 R_L1
Rmu01 8 0 R_mu01
Gm1 5 2 VALUE = {gm1 * V(3,2)}
.end
