spice
* SPICE netlist for the schematic
V1 v_I 0 DC 0
D1 v_I n1 D
D2 n1 v_O D
R1 n1 0 1k
.end
