spice
* SPICE netlist for the schematic

* Resistors
R_rd 5 4 rd
R_rs 3 2 rs

* Capacitors
C_cd 7 3 Cd
C_cj 8 3 Cj

.END
