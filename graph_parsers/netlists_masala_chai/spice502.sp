plaintext
V1 6 8 DC 0   ; Voltage Source Vs connected to nodes 6 and 8
Q1 4 6 2 QNPN ; NPN Transistor with C=4, B=6, E=2
R1 4 5 10k    ; Resistor of 10kΩ connected to nodes 4 and 5
