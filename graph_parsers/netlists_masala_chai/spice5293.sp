plaintext
* Resistors Network

R1 11 8 100
R2 4 9 100
R3 10 6 100
R4 7 3 100
R5 2 5 100

* Connections
* A node: 11, 4, 10, 7, 2
* B node: 8, 9, 6, 3, 5

.end
