spice
* SPICE Netlist for the given circuit

Q1 2 5 5 NPN
RC 2 4 1k
RE 5 4 2k
VCC 6 2 DC 10V
VEE 4 4 DC -10V

.MODEL NPN NPN
.END
