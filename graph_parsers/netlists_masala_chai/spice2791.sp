plaintext
M1 2 Vin 0 NMOS
M2 2 Vb VDD PMOS
CL 2 0 CL_value
