plaintext
* SPICE netlist
Vin 2 5 DC 0
M1 3 2 2 2 NMOS
R1 3 4 R
.ends
