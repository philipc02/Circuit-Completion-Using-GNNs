spice
* Transistors
M1 2 2 3 3 PMOS
M2 2 2 3 3 PMOS
M3 3 2 8 8 NMOS
M4 3 3 8 8 NMOS
M5 2 2 7 7 PMOS
M6 2 5 7 7 PMOS
M7 4 4 7 7 PMOS
M8 6 1 7 7 PMOS
M9 8 9 5 5 NMOS

* Current Source
I1 1 3 DC 200uA

* Capacitors
C1 5 8 5pF

* Resistors
R1 1 6 150
R2 5 5 150
R3 8 3 50
R4 8 8 100
R5 1 2 150
R6 2 4 150
R7 4 4 150
R8 2 3 150
R9 5 8 50

* Voltage Sources
V1 1 0 DC 1.5V
V2 8 0 DC -1.5V

* End of Netlist
