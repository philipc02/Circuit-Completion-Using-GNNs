spice
* Differential pair amplifier

VCC 5 0 DC <VCC_VALUE>
VIN1 1 0 DC <VIN1_VALUE>
VIN2 2 0 DC <VIN2_VALUE>

RC1 5 3 <RC_VALUE>
RC2 5 2 <RC_VALUE>

Q1 3 1 4 NPN
Q2 2 2 4 NPN

RE1 4 4 <RE_VALUE>
RE2 4 4 <RE_VALUE>
RSS 4 0 <RSS_VALUE>

.model NPN NPN (BF=100)

.END
