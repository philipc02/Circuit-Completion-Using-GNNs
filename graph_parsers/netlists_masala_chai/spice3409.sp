spice
* Transistors
Q1 4 5 7 NPN
Q2 2 3 7 NPN
Q3 2 6 9 NPN
Q4 4 2 7 NPN

* Voltage Sources
vY 10 8 DC 0
VCC 4 0 DC VCC

* Capacitors
C1 5 6 C1
C0 9 2 C0
CE 7 0 CE

* Resistors
R11 4 6 R11
R22 6 5 R22
RT 10 5 RT
RL 9 7 RL
R912 4 2 R912
R922 2 3 R922

* End of Netlist
