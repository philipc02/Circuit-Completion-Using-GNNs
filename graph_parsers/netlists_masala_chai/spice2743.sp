plaintext
* SPICE Netlist

* NMOS Transistor
M1 2 2 6 6 NMOS

* PMOS Transistors
M2 5 4 5 5 PMOS
M3 5 5 4 4 PMOS

* Current Source
I1 3 2 DC 1mA

* Capacitor
C1 4 0 1uF

* Voltage Source
VDD 5 0 DC 5V

* Input Impedance
Vin 2 0 AC 1
