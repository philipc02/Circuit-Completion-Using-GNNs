spice
* Spice netlist for the given circuit

M1 2 4 0 0 NMOS
V1 4 0 DC 0.9
Ix 2 3 DC 1mA

* End of netlist
