spice
* PMOS Transistor M10
M10 4 2 3 3 PMOS_MODEL

* NMOS Transistor M12
M12 3 2 0 0 NMOS_MODEL

* Capacitor Cc
Cc 2 3 4.5pF

* Voltage supply VDD
VDD 4 0 DC VDD_VALUE

* End of Netlist
