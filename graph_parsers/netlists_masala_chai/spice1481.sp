spice
* SPICE Netlist

VCC VCC 0 DC 2.5V
IREF 5 0 DC 1mA

* Transistors
QREF 2 5 4 NPN
Q1 3 2 0 NPN

* Resistor
RP 4 0 1000 ; Assuming RP is 1k ohm (value not specified)

* End of Netlist
