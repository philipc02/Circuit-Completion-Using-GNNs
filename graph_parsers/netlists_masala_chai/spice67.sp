* SPICE Netlist for the given Schematic

VCC 5 0 DC VCC
IBIAS 1 0 DC IBIAS

* NPN Transistor Q1
Q1 6 2 1 NPN

* NPN Transistor Q2
Q2 4 2 3 NPN

* Input and Output
VIN 2 0 DC 0
ROUT 3 0 1k

.END
