spice
* Components
M1 6 7 2 2 NMOS
M2 6 4 1 1 NMOS
I1 2 6 DC IBIAS
V1 7 5 DC VIN1
V2 4 2 DC VIN2
VREF 6 3 DC VREF

* Voltage Supplies
VPLUS 6 0 DC +V
VMINUS 0 2 DC -V

* End of File
