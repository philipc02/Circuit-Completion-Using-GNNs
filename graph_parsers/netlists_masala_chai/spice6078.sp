plaintext
* Differential Amplifier Circuit

* NMOS Transistors (Drain, Gate, Source)
M1 6 1 8 VSS NMOS
M2 4 2 8 VSS NMOS
M7 3 3 8 VSS NMOS
M8 9 9 10 VSS NMOS

* PMOS Transistors (Drain, Gate, Source)
M5 2 2 6 VDD PMOS
M3 1 2 6 VDD PMOS
M6 10 2 4 VDD PMOS
M4 4 2 6 VDD PMOS

* Current Source
I1 8 8 DC

* Voltage Rails
VDD VDD 0 DC
VSS VSS 0 DC
