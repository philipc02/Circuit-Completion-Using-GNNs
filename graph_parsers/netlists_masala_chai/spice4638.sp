spice
* SPICE Netlist for the given circuit

VS 4 2 DC 10
D1 2 3 1N4001
RL 3 4 1k

.model 1N4001 D
.end
