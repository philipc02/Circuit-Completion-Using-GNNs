* SPICE Netlist for Differential Pair

* Transistors
Q1 6 1 3 NPN
Q2 4 2 3 NPN
Q3 9 6 5 NPN
Q4 88 66 22 NPN
Q5 3 3 7 NPN
Q6 5 17 7 NPN

* Current Source
I_BIAS V_CC 9 DC 1mA

* Voltage Sources
V1 1 0 DC 0V
V2 2 0 DC 0V
VCC 88 0 DC 15V
VEE 17 0 DC -15V

* End of Netlist
