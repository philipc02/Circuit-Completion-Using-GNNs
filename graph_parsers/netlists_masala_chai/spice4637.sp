plaintext
* Simple Circuit
VTH 7 6 DC 12V
R1 2 7 10k
D1 3 2 D
RL 4 3 1k
