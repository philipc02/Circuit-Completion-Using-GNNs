spice
* Op-Amp Integrator Circuit
* Components
Rin 1 2 22k
Rf 3 4 330k
Cin 5 6 10n

* Connections
XU1 0 1 2 OpAmp

* Net Connections
* Op-Amp terminals: Non-inverting = 0, Inverting = 1, Output = 2
* Non-inverting input of Op-Amp connected to ground
Vground 0 2 0

* Voltage output
Vout 2 7 DC 0
