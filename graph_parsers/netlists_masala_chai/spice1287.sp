plaintext
* NMOS Transistor Definitions
M1 Vout Vin 2 2 NMOS W=20u L=0.18u
M2 2 0.8V 0 0 NMOS W=10u L=0.18u

* Voltage Source
VDD Vout 0 DC 1.8
V1 0.8V 0 DC 0.8

* DC Analysis
.OP

* End of Netlist
.END
