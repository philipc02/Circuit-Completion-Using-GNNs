spice
* NMOS Transistors
M1 3 2 4 4 NMOS W=?? L=??
M2 4 2 4 4 NMOS W=?? L=??

* PMOS Transistors
M3 2 3 7 7 PMOS W=?? L=??
M4 2 3 7 7 PMOS W=?? L=??
M5 5 6 7 7 PMOS W=?? L=??
M6 8 7 7 7 PMOS W=?? L=??

* Current Source
I1 4 0 DC Iss

* Resistors
R1 5 0 RD
R2 8 0 RD

* Capacitors
C1 5 0 CL
C2 8 0 CL

* Voltage Source
V1 7 0 DC VDD

* Input Voltage
Vin 2 0 DC 0
