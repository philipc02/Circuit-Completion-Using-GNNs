spice
* BJT Amplifier Circuit

VCC 3 6 DC 5V

R1 3 2 1k
RC 3 4 1k
R2 2 6 1k

Q1 4 2 5 NPN

*.end
