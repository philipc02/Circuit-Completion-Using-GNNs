spice
* Components
R1 4 2 R1
C1 2 3 C1
L1 2 0 L1
V1 1 4 Vin
* Connections
Vin 1 0 DC 0
Vout 2 0
