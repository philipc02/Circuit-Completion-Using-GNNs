spice
* Transistors
M1 2 9 2 2 PCH W=5u L=0.5u
M2 2 7 3 3 PCH W=5u L=0.5u
M3 2 8 4 4 PCH W=5u L=0.5u
M4 2 4 9 9 PCH W=5u L=0.5u
M5 4 5 9 9 NCH W=5u L=0.5u
M6 3 6 0 0 NCH W=5u L=0.5u
M7 0 9 6 6 NCH W=0.5u L=4u

* Current Source
I1 6 0 DC 2.5uA

* Voltage Sources
VDD 9 0 DC 5V
VSS 5 0 DC 0V

* Capacitors
C1 5 7 30f
C2 5 8 30f

* End of netlist
