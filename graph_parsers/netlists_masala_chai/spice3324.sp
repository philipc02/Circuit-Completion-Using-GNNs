* SPICE Netlist

VDD 4 0 DC 5V
Vin 5 0 DC 1.2V

* PMOS
M2 3 2 4 4 PMOS

* NMOS
M1 3 5 0 0 NMOS

* End of Netlist
