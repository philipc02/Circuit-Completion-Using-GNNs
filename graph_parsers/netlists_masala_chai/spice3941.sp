plaintext
* SPICE Netlist

* Voltage Source
Vs 8 2 DC 0

* Resistors
RS 8 4  R_S
Ri 4 2  R_i
Ro 2 6  R_O
RL 6 3  R_L

* Dependent Voltage Source
E1 2 2 4 2 Av

* Ground
V_gnd 2 0 DC 0

.end
