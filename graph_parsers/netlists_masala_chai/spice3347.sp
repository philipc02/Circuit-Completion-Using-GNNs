* SPICE netlist

* Current Sources
I1 E 2 I_E
I2 2 B I_CS

* Dependent Voltage Source
E1 2 C VALUE = {alpha_f*I(E)}

.END
