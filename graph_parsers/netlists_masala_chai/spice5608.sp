plaintext
* SPICE Netlist for Given Circuit

V1 4 0 DC 5V
R1 4 2 2.5k
D1 2 5 D
I1 2 0 DC

.model D D
