spice
* NMOS Transistors
M1 2 3 4 4 NMOS
M2 6 2 5 5 NMOS
MF 7 3 3 3 NMOS

* Resistors
RD1 22 2 1k
RD2 22 8 1k

* Current Source
Iin 7 3 DC 1mA

* Voltage source
VDD 22 0 DC 5V

* Output
Vout 8 0 DC
