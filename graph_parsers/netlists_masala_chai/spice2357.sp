* PMOS Transistors
M1 8 4 10 10 PMOS
M2 8 4 9 9 PMOS

* NMOS Transistors
M3 2 2 4 4 NMOS
M4 2 2 7 7 NMOS
M5 3 3 5 5 NMOS
M6 3 3 11 11 NMOS

* Net Definitions
VDD 10 0 DC 5
VSS 7 0 DC 0

* Model Definitions
.model PMOS PMOS
.model NMOS NMOS

* End of Netlist
