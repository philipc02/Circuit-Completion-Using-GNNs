spice
* SPICE Netlist for the given schematic

* Voltage source
VDD 3 0 DC VDD

* Resistors
RS 3 5 R_S_value
RL 4 0 R_L_value

* Capacitors
CE 3 3 C_E_value
CL 4 0 C_L_value

* MOSFET
M9 3 3 4 4 NMOS_MODEL

* End of netlist
