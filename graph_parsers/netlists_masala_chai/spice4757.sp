spice
* SPICE Netlist
* NPN Transistor Circuit

Q1 2 5 3 NPN

RB 5 0 2.7k
RC 2 1 3.6k
RE 3 4 1k

VCC 1 0 DC 10V
VEE 4 0 DC 2V

.model NPN NPN
.end
