spice
* List of components from the schematic
* Transistors
M1 4 3 5 5 NMOS
M2 4 8 5 5 NMOS
M3 4 4 3 3 PMOS
M4 4 7 3 3 PMOS
MG 6 5 8 8 NMOS
MT 5 2 6 6 NMOS

* Current Sources
I1 4 4 20uA
ISS 2 5 20uA

* Voltage Sources
Vtot 7 3 0V
Vref 5 6 0V

* Resistors
R1 7 8 20k
R2 8 9 20k
R3 9 6 20k
R4 6 10 20k

* End of netlist
