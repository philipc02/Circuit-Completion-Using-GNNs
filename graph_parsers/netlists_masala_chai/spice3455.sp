plaintext
* SPICE Netlist
Vin 5 7 DC <V_value> ; Define the DC value of the voltage source
Ibeta 4 3 <I_value> ; Define the current value for βniD Vin
Rtotal 8 6 <R_value> ; Define the resistance value for RinD + RML + RL

.END
