plaintext
* NMOS Transistor Circuit

VDD 1 0 DC 25V
RD 1 2 1k
RG 3 2 1MEG
M1 0 3 0 0 NMOS

.model NMOS NMOS (LEVEL=1)

.end
