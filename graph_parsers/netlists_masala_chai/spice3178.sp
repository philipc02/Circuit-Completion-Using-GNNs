spice
* SPICE Netlist
* Q1 and Q2: NPN Transistors

Q1 5 4 0 NPN
Q2 3 5 0 NPN

* Voltage source and resistances could be defined if required
*.MODEL NPN NPN
*.MODEL PNP PNP

.END
