plaintext
* SPICE Netlist for the Circuit

V1 3 2 DC 0
V2 5 4 DC 0
RC1 3 2 1k
RC2 4 2 1k

* Node 2 is ground
.END
