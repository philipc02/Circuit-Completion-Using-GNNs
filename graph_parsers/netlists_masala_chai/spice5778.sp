plaintext
* Transistor (Q1)
Q1 3 2 6 NPN

* Resistors
R1 3 2 3.6k
R2 5 2 43k

* Current Source
I1 2 6 DC 0.5m

* Voltage Source
V1 3 0 DC 3V

* Node Connections
V2 3 0 DC
V1 2 0 DC

* End of File
