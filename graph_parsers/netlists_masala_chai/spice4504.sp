spice
* Operational Amplifier Circuit

* Capacitors
C1 Vi 2 C
C2 2 2 C

* Resistors
R3 2 2 0.707R
R4 2 0 1.414R

* Op-amp
* Assuming an ideal op-amp model
XU1 2 2 Vo opamp

* Voltage source for simulation
Vi Vi 0 DC 0

* Control statements
.op
.END
