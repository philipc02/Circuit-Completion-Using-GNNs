spice
* SPICE Netlist
Vin 1 2 DC 0
R1 3 4 1k
R2 3 2 1k
Vout 3 0

* Specify node 0 as ground
.END
