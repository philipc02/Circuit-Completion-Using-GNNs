* NMOS Transistors
M1 4 7 2 2 NMOS
M2 8 35 2 2 NMOS
M3 9 34 2 2 NMOS

* PMOS Transistors
M4 4 24 3 3 PMOS
M5 28 8 25 25 PMOS

* Voltage Sources
V1 2 0 DC 5
V2 3 0 DC 3.3

.end
