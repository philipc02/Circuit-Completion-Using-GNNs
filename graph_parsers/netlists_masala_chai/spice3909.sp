spice
* SPICE netlist

V1 6 7 DC 2.5V

R1 4 6 40k
R2 2 5 40k
RE 5 7 0.7k
RC 3 1 1.6k

Q1 3 5 1 NPN

*.end
