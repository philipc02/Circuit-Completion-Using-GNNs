spice
* Transistor Amplifier Circuit

VCC 1 0 DC 15
R1 2 4 10k
R2 4 0 2.2k
RC 2 3 2.7k
RE 5 0 1k
Q1 3 4 5 NPN
