*MOSFET
M1 2 1 0 0 NMOS

*Resistor
Rs 0 0 Rs

*Voltage Source
Vb 1 0 DC Vb_value

*Load Resistor
Rout2 2 0 Rout2_value
