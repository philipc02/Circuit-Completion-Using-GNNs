* NMOS Transistor
M1 3 6 2 2 NMOS

* Current Source
I1 3 7 DC 0

* Resistor
Rro 3 5 ro

* Voltage Source
Vx 2 4 DC Vx

* Ground
Vg 4 0 DC 0
