spice
* BJT Amplifier Circuit

VCC 6 0 DC 10V
VS 5 4 DC
RS 5 3 0.7k
RB 2 6 1k
RC 3 4 1k
RE 4 0 1k
CC 3 2 10u

Q1 2 3 4 NPN

* Connections
* Base of Q1 to RB
* Collector of Q1 to CC
* Emitter of Q1 to RE and ground

.END
