* SPICE Netlist
V1 1 0 DC 20
R1 2 1 820
D1 2 0 Zener
