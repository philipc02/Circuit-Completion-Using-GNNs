* SPICE Netlist

* Voltage Sources
VDD 2 0 DC V_DD
V1 3 0 DC V1

* Current Source
IREF X 2 DC I_REF

* Resistors
R1 Y 3 R1
R2 X Y R2

* Transistors
M1 Y 5 0 0 NMOS
M2 X 4 0 0 NMOS

.end
