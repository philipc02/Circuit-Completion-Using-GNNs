spice
* NMOS Transistors
M1 Vout Vin 2 2 NMOS
M2 2 Vb 0 0 NMOS

* Resistor
RD VDD Vout RD_value

* Voltage Sources
VDD VDD 0 DC VDD_value
Vin Vin 0 DC Vin_value
Vb Vb 0 DC Vb_value

.model NMOS NMOS
