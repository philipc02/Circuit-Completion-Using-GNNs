spice
* SPICE Netlist for the given circuit
VBB 3 2 DC 4V
VCC 1 0 DC 10V
RB 3 2 220k
RC 1 4 2k
Q1 4 2 5 NPN
.tran 1ms
.end
