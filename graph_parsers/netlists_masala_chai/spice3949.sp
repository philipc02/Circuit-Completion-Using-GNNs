plaintext
* SPICE Netlist

Vs 5 8 DC 0
R1 5 4 1k
R2 4 7 1k
R_E 4 6 1k
R_C 2 3 1k
V_pi 4 5 DC 0
Gm 2 3 4 5 gm

* Nodes
* 5 - B
* 7 - A
* 8 - D
* 4 - E
* 2 - C
* 3 - V_O
* 6 - Ground

.end
