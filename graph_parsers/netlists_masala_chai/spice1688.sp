spice
*MOSFET Circuit
* PMOS M1
M1 5 4 2 2 PMOS

* NMOS M2
M2 2 3 2 2 NMOS

* Voltage definitions
VDD 5 0 DC VDD
VIN 4 0 DC VIN
VB 3 0 DC VB

.END
