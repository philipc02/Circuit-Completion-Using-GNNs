spice
* SPICE Netlist
VS 4 3 DC 5V
RS 3 3 100
VZ 3 2 D

.model D D (IS=1e-14 BV=5)

*.end
