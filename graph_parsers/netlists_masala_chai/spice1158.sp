plaintext
* SPICE Netlist
V1 vin 0 DC

G1 3 0 vin 0 gm

RD 2 0 RD_value

* Connections
* G1 connects Node 4 to 3
* RD connects Node 2 to 0 (ground)

.END
