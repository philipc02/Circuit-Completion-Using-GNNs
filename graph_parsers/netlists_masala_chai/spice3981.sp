plaintext
* SPICE Netlist

V1 1 5 DC #
CC 1 3 #
IEo 2 4 DC #

Ri 3 1 #
RB 3 5 #
RC 6 3 #

CE 4 7 #
Q1 6 3 2 NPN
Q2 3 3 4 NPN

* Simulation Commands
.end
