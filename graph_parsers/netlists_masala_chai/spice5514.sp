spice
* Op-Amp Inverting Amplifier
Vin 3 0 AC 10m
Rf 4 2 560k
Ri 2 0 1.5k
X1 3 2 4 opamp

* Op-Amp model placeholder
.subckt opamp noninv inv out
* Ideal op-amp model omitted for simplicity; use appropriate model.
.ends opamp

.end
