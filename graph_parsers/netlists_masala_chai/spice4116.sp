spice
* SPICE Netlist
Vi 3 6 DC 0
RS 3 1 1k
CC1 1 7 1u
RE 7 2 10k
V1 4 2 DC 20
RC 7 5 6.5k
CC2 5 9 10u
RL 9 6 5k
V2 2 4 DC 25
Rground 2 0 0

* End of Netlist
