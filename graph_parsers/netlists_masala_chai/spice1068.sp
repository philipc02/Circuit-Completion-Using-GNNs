spice
* Transistor Amplifier

VCC N002 0 DC 15V
Vin N001 0 DC 5V
Vb N003 0 DC 2.5V

Q1 N002 N001 222 N022 NPN
Q2 222 N003 0 N022 NPN

RCS 222 N022 1k
RE N022 0 330

.MODEL NPN NPN (Is=1e-14 BF=100)
.END
