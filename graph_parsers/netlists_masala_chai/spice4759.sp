plaintext
* SPICE Netlist for NPN Transistor Amplifier Circuit

VCC 2 0 DC 10
VEE 4 0 DC -2

RC 5 2 3.6k
RE 6 4 1k
RB 9 8 2.7k

Q1 5 9 6 NPN

* Nodes
* 0 - Ground
* 2 - VCC connection
* 4 - VEE connection
* 5 - Transistor collector
* 6 - Transistor emitter
* 8 - Connection to RB and ground
* 9 - Transistor base

.end
