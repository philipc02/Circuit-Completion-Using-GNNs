spice
Vs 4 5 AC 1V
R1 4 3 1k
C1 3 2 10uF
