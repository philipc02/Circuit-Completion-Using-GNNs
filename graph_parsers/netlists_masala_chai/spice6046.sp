spice
* SPICE Netlist for the circuit
Q7 2 v_o2 9 NPN
R4 3 2 1k
R5 9 4 1k
R14 v_o3 4 1k
