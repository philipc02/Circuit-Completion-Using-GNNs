spice
* SPICE netlist for the given circuit

VDD 5 0 DC <value>
Vin 1 0 DC <value>

Rs 1 2 <value>
RD 5 4 <value>
CF 3 4 <value>

M1 4 2 3 3 NMOS

.end
