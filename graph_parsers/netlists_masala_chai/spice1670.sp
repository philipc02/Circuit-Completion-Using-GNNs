markdown
* Components
M1 3 2 0 0 NMOS
M2 4 3 3 3 PMOS
VDD 4 0 DC 5
Vin 1 0 DC 1
RS 1 2 10k
VB 4 0 DC 2

* Netlist
* M1: NMOS Transistor
* Drain: 3
* Gate: 2
* Source: 0

* M2: PMOS Transistor
* Drain: 3
* Gate: 4
* Source: 3

* VDD: Voltage Source
* Positive: 4
* Negative: 0

* Vin: Voltage Source
* Positive: 1
* Negative: 0

* RS: Resistor
* Node1: 1
* Node2: 2

* VB: Voltage Source for Bias
* Positive: 4
* Negative: 0

.end
