spice
* Differential Sense Amplifier
M1 2 8 1 1 PMOS W=XXX L=YYY
M2 2 9 1 1 PMOS W=XXX L=YYY
M3 2 8 3 3 NMOS W=XXX L=YYY
M4 2 9 3 3 NMOS W=XXX L=YYY

* Capacitors
C1 2 3 VALUE=ZZZ
C2 2 4 VALUE=ZZZ

* Equalization and Precharge Circuitry
M5 6 5 7 7 PMOS W=XXX L=YYY
M6 6 5 7 7 NMOS W=XXX L=YYY

* Voltage Sources and Current sources are not specified explicitly
