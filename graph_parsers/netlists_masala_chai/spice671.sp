plaintext
* Netlist for the given circuit

V1 5 2 DC Vin
VB 5 4 DC VB
R1 4 3 1k
D1 3 2 D

.model D D
