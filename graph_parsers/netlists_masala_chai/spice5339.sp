spice
* Resistors
R1 5 7 1k
R2 7 8 470
R3 8 2 220
R4 3 4 1k

* Voltage Source
Vs 2 5 DC 10

* Analysis
.OP
.END
