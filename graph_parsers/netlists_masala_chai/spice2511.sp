spice
M2 2 3 2 NMOS
Rout 2 2 1000
r01 2 3 1000
