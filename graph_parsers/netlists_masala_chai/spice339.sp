Vi 6 2 DC 0
R1 6 7 z_i
E1 3 5 6 2 a
R2 3 4 z_o
Vo 4 2 DC 0
