Q1 4 2 1 QMODEL
Q2 8 2 1 QMODEL
Q3 3 2 4 QMODEL
Q4 3 2 2 QMODEL
Q5 6 2 5 QMODEL
Q6 3 2 5 QMODEL

I1 4 1 DC 1
I2 8 1 DC 1
I3 4 3 DC 1
I4 3 5 DC 1
I5 5 6 DC 1
I6 6 3 DC 1

VEE 7 0 DC -VEE

.model QMODEL NPN (IS=1E-14 BF=100)
