spice
V1 6 3 DC 0  ; Voltage source V^2_R
R1 3 4 R     ; Resistor R
C1 4 5 C     ; Capacitor C
