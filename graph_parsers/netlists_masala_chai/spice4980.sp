plaintext
* NMOS Amplifier Circuit

VDD 1 0 DC 15V
VAGC 5 0 DC 0V

RD 1 2 1k
RG 5 3 1Meg

Cin 6 3 100n
Cout 2 7 100n

MN1 2 3 4 4 NMOS

Vin 6 0 AC 1

* Values for capacitors assumed
* Other component values as identified
* End of netlist
