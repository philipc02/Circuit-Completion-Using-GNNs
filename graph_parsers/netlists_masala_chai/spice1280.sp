plaintext
* Example SPICE Netlist
VDD 3 0 DC 1.8
RD 3 4 1k
M1 2 Vin 1 1 NMOS L=1u W=1u
I1 Vin 1 DC 10u
