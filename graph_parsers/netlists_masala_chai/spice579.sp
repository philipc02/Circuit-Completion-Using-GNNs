plaintext
* SPICE netlist for the given circuit

V_in 5 2 DC 0
R1 5 3 1k
C1 3 2 1u
R2 3 2 1k
L1 3 2 1m

* Output node is node 2

.END
