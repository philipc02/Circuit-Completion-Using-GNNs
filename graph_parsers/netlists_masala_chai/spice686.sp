spice
* SPICE Netlist
Iin 2 5 DC 0
R1 2 3 1000
D1 2 4 Dmodel
D2 4 0 Dmodel
Vout 2 0

.model Dmodel D
