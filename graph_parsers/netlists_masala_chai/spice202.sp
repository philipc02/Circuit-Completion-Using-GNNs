spice
* Components
Vg1 4 8 DC <value>
Vg2 4 6 DC <value>

Is1 2 3 Gm1
Is2 2 3 Gm2

R1 2 0 ro1
R2 2 0 ro2

Vi 4 3 DC <value>

* Models or any other subcircuit can be defined here

* End of netlist
