spice
* Component Definitions
V1 1 4 DC 24V
RTH 2 1 6k
RL 2 3 RL

* Node Definitions
* 1: Positive terminal of Voltage Source
* 4: Negative terminal of Voltage Source
* 2: Node connected to RTH and RL
* 3: Node connected to RL

.END
