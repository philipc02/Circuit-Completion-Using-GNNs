spice
* Netlist for the PMOS and NMOS transistors
M1 3 4 3 3 PMOS W=30u L=0.18u
M2 3 5 0 0 NMOS W=20u L=0.18u

* Voltage sources
Vb1 4 0 DC <value> ; Replace <value> with the appropriate voltage for Vb1
Vb2 5 0 DC <value> ; Replace <value> with the appropriate voltage for Vb2

* End of Netlist
