spice
* SPICE Netlist for the given circuit

VCC 8 0 DC 5
VS 4 6 AC 1

R1 4 8 53.8k
R2 5 6 10k
RC 3 2 1k

C1 4 5

Q 3 4 6 NPN

.end
