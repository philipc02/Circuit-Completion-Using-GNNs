spice
* SPICE Netlist for the given schematic
V1 3 4 DC V+
R1 3 5 R1
R2 3 6 R2
R3 5 0 R3
RT 6 0 RT
* Node 2 is vO2, Node 5 is vO1
