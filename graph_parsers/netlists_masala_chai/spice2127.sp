spice
* Netlist for the given schematic
V1 5 4 DC 0
R1 4 3 Rs
G1 2 4 5 gm
V2 2 0 0
