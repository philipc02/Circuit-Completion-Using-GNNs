spice
* SPICE Netlist
* Transistors
M9 5 2 VDD 2 PMOS
M10 5 2 VDD 2 PMOS
M11 5 X 2 2 NMOS
M12 5 Y 2 2 NMOS
M3 X 9 0 0 NMOS
M4 Y 9 0 0 NMOS

* Voltage Sources
VDD VDD 0 DC 5V

* End of Netlist
