plaintext
* SPICE Netlist
V1 2 0 DC 0
RF 1 3 1k
E1 3 2 3 2 a
.END
