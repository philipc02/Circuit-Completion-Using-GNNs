* SPICE Netlist
VDD 6 0 DC 5V
Vn3 5 0 DC

* Transistors
M1 2 8 7 7 NMOS
M2 4 2 7 7 NMOS
M3 6 5 8 8 PMOS
M4 6 4 4 4 PMOS

* Nodes
* Node 6: VDD
* Node 5: Vn3 Source Positive Terminal
* Node 0: Ground
* Node 7: Ground Connections for M1 and M2
* Node 2: X
* Node 4: Y
* Node 8: Source Connection for M3 and M1 Gate

.end
