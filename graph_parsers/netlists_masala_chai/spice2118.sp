plaintext
* MOSFET Definitions
M1 2 1 3 3 NMOS
M2 4 1 5 5 PMOS

* Voltage Sources
VDD 5 0 DC VDD

* Node Annotations
* 1 = Vin
* 2 = Vout
* 3 = Ground

.end
