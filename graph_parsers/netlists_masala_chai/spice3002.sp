plaintext
*MOSFET, Current Source, and Capacitors
M1 3 2 1 1 NMOS

*Current Source
I1 4 3 DC 1mA

*Capacitors
C1 3 4 1uF
C2 3 0 1uF

*Voltage Source (Assumed for simulation stability)
VDD 4 0 DC 5V
Vin 2 0 DC 0V

*Simulation Command
.OP
.END
