* SPICE Netlist for the given circuit
   V1 3 4 DC 8
   R1 3 3 3.3k
   R2 3 3 6.2k
   R3 3 6 1k
   R4 6 2 1k
   R5 2 4 680
   R6 2 4 390
   .END
