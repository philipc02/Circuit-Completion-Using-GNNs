* Component List
* Capacitor C
C1 6 5 C

* Voltage Source VB
V1 2 4 DC 5

* Diode D
D1 5 2 Dmodel

* Resistor R
R1 5 3 R

* Ground Connection
V0 3 0 DC 0

* Diode Model
.model Dmodel D

* End of Netlist
