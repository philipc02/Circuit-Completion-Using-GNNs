plaintext
* SPICE Netlist

* Voltage Controlled Current Source
G1 Y 0 Vx 0 gm

* Capacitors
C1 Y 0 Cout
C2 4 0 CY

* Resistor
R1 2 0 RL

* Connections
Vx Vout Y DC 0
