plaintext
* SPICE netlist for the circuit in the provided schematic
* Components
R1 2 2 10k
R2 2 4 R
RL 2 5 RL

* Voltage Controlled Voltage Source (Op-Amp)
E1 5 3 2 3

* Current Source
I1 6 2 DC i_I

* Ground
Vg 3 0 DC 0

* End of netlist
