spice
* SPICE Netlist
Q1 2 1 0 QNPN

RPI 1 0 r_pi

VAC 0 ac

.model QNPN NPN
