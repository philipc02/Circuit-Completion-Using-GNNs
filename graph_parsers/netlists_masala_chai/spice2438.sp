* NMOS transistor M1
M1 2 Vb 0 0 NMOS

* Capacitor C1
C1 2 0 <value>

* Current Source Ix
Ix 2 Vx DC <value>

* Voltage Source Vdd
Vdd 2 0 DC <value>

.end
