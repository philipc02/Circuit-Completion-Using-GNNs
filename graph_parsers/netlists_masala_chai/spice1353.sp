* SPICE Netlist
Q1 3 1 4 NPN
Q2 4 2 VCC NPN
Rout 4 0 ROUT_VALUE
VCC VCC 0 DC_VOLTAGE
