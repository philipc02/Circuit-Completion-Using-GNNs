spice
* SPICE Netlist

* NMOS transistor Q1
M1 3 4 5 5 NMOS

* PMOS transistor Q2
M2 7 3 2 2 PMOS

* Current sources
I1 3 6 DC I
I2 2 5 DC I

* Net definitions
vi 4 0 DC 0
vo 2 0 DC 0

* End of netlist
