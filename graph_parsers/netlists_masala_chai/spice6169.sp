* Transistors
Q1 2 1 8 NPN
Q2 3 2 8 NPN
Q3 5 6 4 NPN

* Resistors
RC1 2 7 9k
RC2 3 2 5k
RC3 5 0 600
RE1 8 4 100
RE2 4 0 100
RF 8 4 640

* Voltage Source
Vs 1 0 DC

* Simulation Commands
.model NPN NPN
.end
