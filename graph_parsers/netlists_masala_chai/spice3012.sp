spice
* NMOS Inverter Circuit

M1 2 Vin 3 3 NMOS
RD VDD 2 1k
VDD VDD 3 DC 5

* End of Netlist
