plaintext
* NMOS & PMOS Inverter Circuit

M1 4 6 3 3 NMOS
M2 4 2 5 5 PMOS

VDD 5 0 DC 5V
VIN 6 0 DC 1.5V
