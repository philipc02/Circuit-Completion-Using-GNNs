* Circuit Netlist
V1 10 8 DC 10

R1 3 6 1k
R2 2 4 2.2k
R3 5 9 1.8k
R4 5 8 330
R5 7 8 680

* Nodes:
* 10 - Positive terminal of voltage source
* 8  - Ground
* 3  - Node between V1 and R1
* 6  - Node between R1 and R2
* 2  - Node between R1 and R2
* 4  - Node between R2 and ground
* 5  - Node between R3, R4 and R5
* 7  - Node between R4 and R5
* 9  - Node between R3 and ground

.END
