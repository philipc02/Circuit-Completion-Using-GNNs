plaintext
* MOSFET definitions
M1 4 6 5 5 NMOS
M2 4 8 5 5 NMOS
M3 2 1 6 6 PMOS
M4 6 2 7 7 PMOS

* Voltage Sources
VDD  2 0 DC VDD
VOSN 3 0 DC VOSN
VOSP 2 3 DC VOSP

* Current Source
I1  5 0 AC 0
