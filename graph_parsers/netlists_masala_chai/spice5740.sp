* NPN transistor circuit
   Q1 5 2 6 NPN

   RC 5 4 1k
   RE 6 3 1k

   VCC 4 0 DC 15
   VEE 6 0 DC -15

   .model NPN NPN
   .end
