plaintext
* Dual BJT Amplifier Circuit

Q1 5 3 6 NPN
Q2 5 4 6 NPN

RC1 5 5 1k
RC2 5 5 1k
RE 6 0 100

VCC 5 0 DC 15
VBE1 3 0 DC 0.7
VBE2 4 0 DC 0.7
VEE 0 0 DC -15

.MODEL NPN NPN

.end
