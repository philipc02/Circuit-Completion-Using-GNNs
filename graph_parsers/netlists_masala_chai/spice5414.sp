plaintext
* SPICE Netlist for the given schematic

L1 5 3 100u
L2 3 6 200u
L3 2 4 400u

.END
