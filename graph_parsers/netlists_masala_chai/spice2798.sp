spice
* Components
C1 3 3 C_GD
V1 1 0 Vin
G1 0 2 3 2 gm
R1 5 3 RG
R2 2 1 RS
R3 3 4 RD

* Nodes
* 1 - Positive terminal of Vin, connected to RS
* 2 - Negative terminal of V1, connected to RS
* 3 - Positive terminal of V1, connected to RG, CGD, and GmV1
* 4 - Ground connection for RD
* 5 - Ground connection for RG
