spice
* Transistors
Q1 3 3 2 NPN
Q2 4 3 5 NPN

* Current Source
IREF 7 3 DC 1mA

* Resistors
R1 7 3 1k
RE1 2 6 1k
RE2 5 6 1k

* Voltage Sources
V+ 7 0 DC 10V
V- 6 0 DC 0V
V_C2 4 0 DC 5V

* End of Netlist
