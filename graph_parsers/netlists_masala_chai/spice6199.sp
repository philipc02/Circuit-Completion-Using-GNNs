V1 2 8 DC Vs
Rin 7 2 10k
Rf 2 3 56k
Rc 3 2 5.6k
Q1 3 2 4 NPN
