Vi 7 6 DC 0
RS 7 3 1k
Cgs 3 6 1p
Cgd 3 5 1p
Gm 5 6 4 6 1e-3
RL 5 5 1k
