spice
* SPICE Netlist
V1 8 0 DC v_in/2
I1 3 3 DC i_in/2
I2 2 4 DC -i_f/2
V2 3 5 DC f*v_o
