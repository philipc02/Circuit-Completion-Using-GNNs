spice
* SPICE Netlist for the schematic
V1 5 0 DC 10V
I1 6 0 DC Ii
I2 4 0 DC 16mA
M1 2 22 2 2 NMOS
M2 5 3 2 2 NMOS
RD 5 2 525
RF 2 4 500
D1 3 4 LED
