spice
* Op-amp based circuit analysis
Vs 6 9 DC 0
RS 6 5 1k
RF 5 33 10k
R0 3 2 10k
E1 2 4 5 7 -a
RL 7 9 1k

* .op to perform the operating point analysis
.op
.end
