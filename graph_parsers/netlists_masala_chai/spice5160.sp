* SPICE Netlist
* Components and connections

* Capacitors
C1 5 2 C
C2 2 0 C

* Resistors
R1 5 0 R
R2 2 0 R
R3 2 3 R1
R4 2 4 R2

* Operational Amplifier
* Ideal op-amp model
* Note: Actual implementation requires specific op-amp model
X1 3 2 2 4 OPAMP

* Voltage Source
Vin 5 0 DC 0

* Note: Ensure OPAMP model is included in the library
