plaintext
* NMOS Transistors
M1 3 3 0 0 NMOS
M5 2 3 4 4 NMOS
M3 2 5 4 4 NMOS
M1' 3 5 5 5 NMOS

* Voltage Source
V1 5 0 DC Vdd/2
