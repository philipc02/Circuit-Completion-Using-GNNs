spice
* Component Definitions
QREF 2 2 0 PNP
QI1 2 3 0 NPN
IREF 2 0 DC <value>
RP 3 0 <resistance_value>

* Voltage Reference
VCC 0 2 DC <value>

* End of Netlist
.end
