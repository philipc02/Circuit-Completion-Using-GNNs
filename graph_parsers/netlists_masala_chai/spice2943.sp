* SPICE Netlist
M1 5 P 3 3 NMOS
M2 4 2 3 3 PMOS
C1 4 3 C1_value
C2 P 0 C2_value
VDD 4 0 DC VDD_value
RD 4 Vout R_value
Iin 3 0 DC Iin_value
