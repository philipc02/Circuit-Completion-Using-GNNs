plaintext
* NMOS Amplifier Circuit

VDD 3 0 DC 1.8V
RD 3 2 1k
Vin 1 0 DC 0V

M1 3 1 0 0 NMOS_MODEL

.model NMOS_MODEL NMOS (LEVEL=1)

.end
