plaintext
* SPICE Netlist

* Voltage Sources
V_CC 5 0 DC VCC
V_BIAS 1 0 DC VBIAS

* Resistors
RC1 5 4 RC
RC2 3 2 RC

* Transistors
Q3 5 4 1 NPN
Q4 3 2 1 NPN
Q6 1 5 0 NPN

* End of Netlist
