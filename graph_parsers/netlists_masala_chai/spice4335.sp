spice
* SPICE Netlist
Q1 3 v1 4 QNPN
Q2 v_o2 v1 4 QNPN
Q3 V+ 3 5 QNPN
Q4 V+ 3 v_o2 QNPN
I1 4 V- DC IQ
