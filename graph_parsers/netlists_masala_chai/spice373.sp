* Voltage Sources
V1 1 5 DC <value>
V2 4 3 DC <value>

* Current Sources
I1 1 0 DC <value>
I2 4 3 DC <value>

* Resistors
RF 1 6 <value>
RE 5 2 <value>
