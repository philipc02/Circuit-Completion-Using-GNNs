I1 2 4 DC I
D1 2 3 Dmodel
R1 3 4 10k
V1 2 0 DC 3
V2 4 0 DC -3
.model Dmodel D
