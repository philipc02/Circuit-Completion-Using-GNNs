plaintext
* SPICE Netlist

* Current Source
I1 2 3 DC g_m*V_in

* Resistor Ro
R1 4 6 Ro

* Connections
Vg 1 2 DC Vg
Vd 7 6 DC Vd
Vs 3 1 DC 0
Vb 5 3 DC 0
