spice
* NPN Transistor Amplifier Circuit

VCC 3 0 DC 10

R1 3 2 10k
R2 2 0 2.2k
RC 3 4 3.6k
RE 4 5 1k

Q1 4 2 5 5 2N3904

.model 2N3904 NPN
.END
