spice
* NMOS Transistor
M1 3 4 0 0 NMOS

* Voltage Source
VDD 2 0 DC VDD

* Capacitors
CF 3 2 C_F
Cin 3 0 C_in
