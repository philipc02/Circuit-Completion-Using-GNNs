plaintext
* Voltage Source
Vi 8 6 DC

* Resistors
RG 7 5
RS 3 6
RD 4 2
RL 4 2

* Current Source (controlled)
Gm 4 3 Vgs 1

* Specify node voltages
Vgs 5 3 DC

* Additional connections for clarity
* Assume all unspecified resistor values, and the transconductance gain g_m are given or need to be defined.

.END
