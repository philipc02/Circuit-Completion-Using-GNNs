plaintext
* Transistor
Q1 2 7 8 NPN

* Resistors
Rsig 5 7 R_sig
Rc 6 2 R_c
Re 8 9 R_e

* Voltage Source
Vsig 5 0 v_sig

* Nodes
* 2 - Collector
* 7 - Base
* 8 - Emitter
* 5 - Signal Input
* 6 - Connected to Rc
* 9 - Ground for Emitter
