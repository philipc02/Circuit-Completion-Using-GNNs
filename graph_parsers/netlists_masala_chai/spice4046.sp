* SPICE Netlist

* Voltage Source
Vi 6 0 DC 0

* Resistors
RG 6 2 200k
RS 2 0 100
RD 2 5 1000
RL 5 7 1000

* Capacitor
CL 3 0 1u

* VCCS
Gm 2 0 2 0 gm

.END
