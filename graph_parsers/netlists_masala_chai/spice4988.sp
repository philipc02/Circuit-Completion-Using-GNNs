spice
* NMOS Q1
M1 1 2 5 5 NMOS

* PMOS Q2
M2 5 2 3 3 PMOS

* Voltage Source
VDD 1 3 DC 15

* Resistor RG
RG 2 3 1MEG

* Model Definitions
.model NMOS NMOS
.model PMOS PMOS

.end
