* Components
V1 7 10 DC
Q1 2 5 4
RC 8 9 3.3k
RE 2 4 3.6k
R1 5 7 100k
R2 5 2 100k
C1 5 2 inf
C2 9 2 inf

* Supply Voltage
VCC 8 0 DC 5V

* Output Nodes
VO1 0 4
VO2 0 9

* Input Voltage
VI 7 0

.end
