plaintext
* SPICE Netlist
VS 5 8 DC 10
V1 3 4 DC 0.7
RB 3 2 0.23
RL 2 6 1k
