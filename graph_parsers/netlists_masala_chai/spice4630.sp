VTH 1 4 DC <value>
RTH 1 2 <value_RTH>
D1 2 6 D_model
RL 6 3 <value_RL>
