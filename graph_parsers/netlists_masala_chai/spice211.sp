spice
* Voltage Source
Vs 1 0 DC

* Resistors
R1 1 2 R1_value
R2 2 3 R2_value

* Current Sources
I1 1 2 I1_value
I2 2 3 I2_value

* Operational Amplifier
XOP 2 0 3 4 opamp

* Ground
.option gnd 0
