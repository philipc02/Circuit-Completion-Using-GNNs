plaintext
* NMOS Amplifier Circuit
VDD 2 0 DC VDD
Vin 1 0 DC Vin
RD 2 2 RD
M1 2 1 0 0 NMOS L=L1 W=W1
.model NMOS NMOS
.end
