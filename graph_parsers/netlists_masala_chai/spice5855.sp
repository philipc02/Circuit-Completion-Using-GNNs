spice
* Transistor
Q1 2 1 3 NPN

* Resistors
RC 1 2 R_C
RE 3 2 R_E
Rsig 5 3 R_sig
RL 4 0 R_L

* Capacitors
CC1 5 2 C_C1
CC2 4 2 C_C2

* Voltage Source
Vsig 5 0 DC V_sig

* Power Supplies
VCC 1 0 DC V_CC
VEE 3 0 DC -V_EE

* End of Netlist
