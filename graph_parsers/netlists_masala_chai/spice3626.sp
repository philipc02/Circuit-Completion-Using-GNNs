* SPICE Netlist
C1 1 2 1uF
D1 2 4
R1 3 5 100k
V1 7 4 5V
VI 1 7 DC 0V

* Net Definitions
* 1: Input of the Capacitor and VI
* 2: Junction of C1 and D1
* 3: Junction of D1 and R1
* 4: Ground
* 5: Output (Vo)

.END
