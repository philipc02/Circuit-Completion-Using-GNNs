plaintext
* SPICE Netlist
VS 3 0 DC <value_of_VS>
R1 3 2 <value_of_R>
D1 2 0 diode_model

.model diode_model D
