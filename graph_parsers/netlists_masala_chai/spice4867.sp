* Netlist for the circuit

* Voltage source
Vin 3 0 AC 1

* Resistors
RE 3 2 1k
re_prime 2 4 100
RC 5 7 1k
RL 7 2 1k

* Current sources
Ie 2 4 DC 1m
Ic 5 6 DC 1m

* Connect output node
Vout 2 0

* End of netlist
