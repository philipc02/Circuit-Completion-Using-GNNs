* Netlist for schematics
Vx 3 0 DC 0
Ix 3 4 DC 0
V1 4 0 DC 0
Gm 2 4 2 0 g
Rd 2 0 RD

* End of netlist
