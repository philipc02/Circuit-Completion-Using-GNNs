plaintext
* SPICE Netlist
V1 9 5 DC 0V
RD 6 3 1k
RL 2 8 1k
RF 8 7 1k

M1 3 4 2 2 NMOS
M2 2 3 2 2 NMOS

.END
