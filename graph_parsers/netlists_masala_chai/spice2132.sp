spice
* NMOS Devices
M1 3 Vb2 3 3 NMOS
M2 3 Vb1 2 2 NMOS

* Resistor
Rout 3 0 Rout
