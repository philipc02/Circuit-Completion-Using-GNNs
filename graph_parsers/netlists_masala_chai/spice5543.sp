* SPICE Netlist
V1 5 2 DC 10V
V2 4 2 DC 5V

R1 2 5 10k
R2 2 4 5k
R3 2 3 2k

.end
