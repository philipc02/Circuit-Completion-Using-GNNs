spice
* Components Declaration
M1 2 5 0 0 NMOS
M2 5 5 6 6 NMOS
M3 4 3 2 2 NMOS
M4 6 3 7 7 NMOS
I1 7 0 DC I_REF

* Nodes Legend
* 0: Ground
* 1: Not used
* 2: Drain of M3 and Q
* 3: Gate of M3 and M4
* 4: Source of M3, connects to I_O
* 5: Common Gate of M1 and M2
* 6: Source of M2, Drain of M4
* 7: Top terminal of I_REF (current source)

* End of Netlist
