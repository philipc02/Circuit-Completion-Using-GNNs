plaintext
M1 2 2 3 3 NMOS
RD 4 2 RD_VALUE
CL 3 3 CL_VALUE
VDD 4 0 DC VDD_VALUE
