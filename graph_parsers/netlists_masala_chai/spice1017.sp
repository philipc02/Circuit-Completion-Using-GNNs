plaintext
* SPICE Netlist

Q1 3 2 4 NPN

R1 5 2 [R1_value]
R2 2 4 [R2_value]

.END
