spice
* Transistors
M1 2 1 0 0 NMOS
M2 3 2 0 0 NMOS
M3 0 5 3 3 PMOS
M4 0 3 3 3 PMOS
M5 0 6 5 5 PMOS
M6 3 3 6 6 PMOS
M7 0 7 2 2 NMOS
M8 0 7 2 2 NMOS
M9 2 2 2 2 NMOS
M10 2 Vout1 0 0 NMOS
M11 2 Vout2 0 0 NMOS
M12 2 3 0 0 NMOS
M13 2 2 3 3 NMOS
M15 2 Vin 1 1 NMOS
M16 2 VREF 1 1 NMOS

* Current Source
I1 1 7 DC 0
