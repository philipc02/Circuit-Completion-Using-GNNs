plaintext
I1 4 3 DC I_sig
R1 2 3 R_sig
Q1 2 4 3 NPN
RC 2 0 RC
