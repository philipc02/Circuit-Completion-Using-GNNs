plaintext
* SPICE Netlist
V1 1 0 DC Vs
R1 1 3 1000 ; Replace 1000 with the actual resistance value of R1 if known
R2 3 4 1000 ; Replace 1000 with the actual resistance value of R2 if known
D1 3 2 D_ZENER ; Model for Zener diode needs to be defined as D_ZENER
