spice
* BJT Amplifier Circuit

* Transistors
Q1 5 1 7 NPN_IS
Q2 4 5 3 NPN_IS
Q3 6 3 2 NPN_IS

* Resistors
RC1 2 7 0.30k
RC2 2 3 0.65k
RF 3 4 1.2k
RE 5 0 50
Rif 1 0 50k ; Assuming some arbitrary input resistance
Rof 4 6 50k ; Assuming some arbitrary output resistance
