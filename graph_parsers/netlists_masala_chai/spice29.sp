plaintext
* SPICE Netlist
V1 4 3 DC av_v1
R1 3 2 Z0
V2 2 4 DC v2
