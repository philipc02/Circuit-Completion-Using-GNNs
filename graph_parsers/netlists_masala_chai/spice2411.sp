plaintext
* SPICE Netlist
M1 5 2 9 9 NMOS
C_GD 5 2 C_GD_Value
C_GS 2 9 C_GS_Value
C_DB 5 4 C_DB_Value
C_SB 9 4 C_SB_Value
C_GB 2 4 C_GB_Value
