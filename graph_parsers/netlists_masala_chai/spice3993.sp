plaintext
* SPICE Netlist

Q1 4 2 3 NPN
RB 2 3 100k

* Nodes:
* 2: Base of NPN and one end of RB (connected to Ri)
* 3: Emitter of NPN and connected to Ground
* 4: Collector of NPN (connected to V+)

.end
