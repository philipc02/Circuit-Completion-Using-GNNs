spice
* NMOS Circuit
M1 3 5 4 4 NMOS
V1 4 0 DC 1V
V2 2 0 DC 0.6V
