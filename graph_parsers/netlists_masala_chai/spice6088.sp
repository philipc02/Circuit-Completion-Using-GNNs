spice
* SPICE Netlist

R1 5 3 (RBparRSig)/(beta+1)
R2 3 2 re
R3 4 8 RE
C1 6 7 CE

* Ground node is node 8
