spice
* NMOS Transistor
M1 2 0 4 4 NMOS

* Resistors
RD 3 2 RD
RS 2 4 RS

* Voltage Sources
V1 3 0 DC 1
V2 4 0 DC -1

* End
