* SPICE Netlist for the Circuit

* Current Source
Iret 7 2 DC 0

* Voltage Controlled Current Source
Gm 2 4 2 7 Gm

* Inductor and Parallel Resistor
L1 5 3 L1
Rp 5 3 Rp

* Current Source
Itest 5 0 DC 0

* Capacitors
C1 4 3 C1
C2 4 0 C2

* Node Voltages
Vpi 7 2 DC Vpi

* End of Netlist
