* Netlist for given schematic

Vin 3 8 DC 0
C1 3 5 1uF
D1 5 4 Dmodel
Vout 3 2 DC 0
