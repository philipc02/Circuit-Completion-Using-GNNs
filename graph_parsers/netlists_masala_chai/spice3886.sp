plaintext
* NPN Transistor Circuit
Q1 2 3 4 NPN

* Resistor
RE 4 2 1.5k

* Voltage Sources
VBB 3 6 DC 0.2
VP 5 0 DC 2

* Ground
Vgnd 0 6 DC 0

.model NPN NPN
.end
