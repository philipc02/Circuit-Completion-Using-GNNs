spice
* Transistors
M1 5 10 6 6 NMOS W=w L=l
M2 3 4 4 4 NMOS W=w L=l

* Resistors
RD1 7 5 RD
RD2 7 3 RD

* Voltage Source
VDD 7 0 DC VDD

* Current Source
I1 6 9 DC 2I
