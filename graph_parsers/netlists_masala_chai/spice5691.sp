plaintext
* MOSFET Amplifier Circuit

VDD 3 5 DC 10V
RG1 3 1 10MEG
RG2 3 5 10MEG
RD 4 1 6k
RS 2 5 6k

M1 1 3 2 2 NMOS

*.model NMOS NMOS
.end
