* Simple NPN Transistor Circuit
VCC 2 0 DC 10V
I1 2 Vout DC 1mA
Q1 Vout Vin 0 Q1_Model

.model Q1_Model NPN
