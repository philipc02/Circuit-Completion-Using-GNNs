spice
* SPICE Netlist

* Components
L1 3 7 135mH
C1 3 2 187nF
R1 3 5 600
V1 7 0 AC

* Nodes
* 0 - Ground
* 2 - Capacitor to ground
* 3 - Common node for inductor, capacitor, and resistor
* 5 - Resistor connection
* 6 - Resistor to ground
* 7 - Inductor and voltage source connection
