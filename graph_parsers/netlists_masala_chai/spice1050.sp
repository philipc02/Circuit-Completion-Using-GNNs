spice
* Netlist for the given schematic
VCC 4 0 DC
Vin 1 0 DC

* NPN Transistor Q1
Q1 2 3 0 NPN

* PNP Transistor Q3
Q3 4 2 2 PNP

* Resistors
RC 2 2 10k
RS 1 3 1k
RE 3 0 1k

.END
