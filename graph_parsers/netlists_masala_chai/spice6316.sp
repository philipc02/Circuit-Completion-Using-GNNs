* PMOS Transistors
M1 NET5 PHI VDD VDD PMOS
M2 NET3 PHI VDD VDD PMOS

* NMOS Transistors
M3 NET4 A NET4 GND NMOS
M4 NET2 YI NET4 GND NMOS
M5 GND PHI GND NMOS
M6 GND PHI GND NMOS

* Capacitors
C1 NET4 YI CL1
C2 NET2 GND CL2

* Voltage Source
VDD VDD GND DC 1.8V

* .END
