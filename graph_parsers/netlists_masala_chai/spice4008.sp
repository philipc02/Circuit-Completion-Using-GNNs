* SPICE Netlist

VCC 8 0 DC VCC
Vs 7 0 DC 0
Is 5 7 DC 0

R1 10 5 R1_value
R2 5 12 R2_value
RE 9 4 RE_value
Ro 3 2 Ro_value
RL 3 2 RL_value

C1 5 7 C1_value
C2 4 3 C2_value

Q1 9 5 4 NPN

* End of Netlist
