spice
Issu 5 2 DC <value> AC <value> ; Define the current value as needed
I1 3 2 DC <value> AC <value>    ; Define the current value as needed
CF 2 2 <CF_value>     ; Define the capacitance value
CL 2 4 <CL_value>     ; Define the capacitance value
Mout 2 2 4 4 NMOS     ; NMOS: Drain Gate Source Body
