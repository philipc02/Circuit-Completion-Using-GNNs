spice
I1 1 4 i_tail
I2 5 2 gm_vgs
R1 2 3 r_o
V1 3 0 vs
