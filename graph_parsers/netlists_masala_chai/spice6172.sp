spice
I1 9 0 DC 1A ; Current source (I_i)

R1 8 3 Rs ; Resistor Rs
R2 7 5 RF ; Resistor RF
R3 4 2 Rid ; Resistor Rid

V1 9 0 DC 0V ; Reference voltage, typically needed for SPICE input
