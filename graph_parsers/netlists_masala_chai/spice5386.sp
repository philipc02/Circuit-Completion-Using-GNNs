spice
* Circuit Netlist

* Voltage Source
Vs 6 9 AC 10 SIN(0 10 300)

* Capacitors
C1 6 4 0.01uF
C2 4 9 0.022uF
C3 4 3 0.015uF
C4 3 2 0.047uF
C5 3 5 0.01uF
C6 3 9 0.015uF

.END
