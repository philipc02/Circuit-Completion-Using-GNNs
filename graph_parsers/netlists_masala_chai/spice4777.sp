* SPICE Netlist for the BJT Circuit

VBB 1 0 DC VBB
VC 2 0 DC VC

Q1 1 2 0 NPN

RC 2 3 RVAL

* Connections
* 1 - Base of Q1 and VBB
* 2 - Collector of Q1 and one terminal of RC
* 3 - Other terminal of RC

.end
