* SPICE Netlist
* Transistor Q1 (PMOS)
M1 5 2 2 2 PMOS

* Transistor Q2 (NMOS)
M2 2 4 3 3 NMOS

* Current Source 2I
I1 5 6 DC 2I

* Current Source I
I2 2 3 DC I

* Voltage Source VBias
V1 4 2 DC VBIAS

*.END
