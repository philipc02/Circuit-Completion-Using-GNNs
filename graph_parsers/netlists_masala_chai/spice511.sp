* Op-amp Inverting Amplifier Circuit
Vs 4 2 DC <value>
Vo 2 3 DC <value>
R1 4 2 <value>
R3 2 2 <value>
XU1 2 2 2 opamp
.END
