spice
* BJT Amplifier Circuit
VCC 3 0 DC 5V
VS 6 0 AC 1V

R1 3 7 1k
R2 7 9 1k
RE 4 0 1k
RO 5 8 1k
RL 8 0 500

C1 6 7 10uF
C2 4 5 10uF

Q1 2 7 4 QNPN

.model QNPN NPN
