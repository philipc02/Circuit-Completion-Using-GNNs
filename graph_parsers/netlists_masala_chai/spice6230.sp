plaintext
* NMOS and PMOS Circuit

* Voltage Sources
V1 4 0 DC 5V
V2 0 2 DC 5V

* MOSFETs
M1 4 2 3 3 NMOS  ; Q1 NMOS - Drain=4, Gate=2, Source=3
M2 3 2 2 2 PMOS  ; Q2 PMOS - Drain=3, Gate=2, Source=2

* End of Netlist
