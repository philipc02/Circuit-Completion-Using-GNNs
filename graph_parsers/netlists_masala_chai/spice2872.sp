spice
* SPICE Netlist

VDD 5 0 DC VDD

RD1 5 3 RD1
RD2 5 4 RD2

M1 3 0 6 6 NMOS
M2 4 0 7 7 NMOS

I_n1 3 1 DC In1

* Additional connections
* Vn_out node is annotated as 3.
