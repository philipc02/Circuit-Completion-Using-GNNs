spice
* Components
V1 2 6 DC Vs
R1 2 9 680
R2 2 7 330
I1 3 2 DC 20m

* Nodes
* 2: Node connecting V1, R1, R2, and I1
* 3: Positive side of I1
* 5: Ground node for R2 and I2
* 6: Negative side of V1
* 7: Bottom node of R2
* 9: Bottom node of R1

.end
