spice
* SPICE Netlist
Vf 1 0 DC 0
RF 1 2 1k
RE1 2 3 1k
RE2 2 4 1k
Io 5 2 DC 1mA
