spice
* Op-amp Circuit

* Voltage Sources
VCC 2 4 DC 12V
VEE 3 4 DC -12V

* Resistors
R1 2 4 1k
R2 2 4 100k

* Op-amp
XOPAMP 2 4 3 5 OPAMP_MODEL

* Model definition for the op-amp
.model OPAMP_MODEL opamp
