* SPICE Netlist for the Given Schematic

* Voltage Sources
Vn 8 0 AC 1
Vs1 6 0 DC
Vs2 3 0 DC

* Resistors
R1_1 6 5 R1_value
R3_1 2 4 R3_value
R1_2 3 2 R1_value
R3_2 2 7 R3_value

* Capacitors
Cip_1 5 8 Cip_value
Cip_2 8 3 Cip_value

* Operational Amplifier
XOPAMP 5 2 4 7 OPAMP

* End of Netlist
