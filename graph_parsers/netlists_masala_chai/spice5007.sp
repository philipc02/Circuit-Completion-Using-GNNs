* NMOS Transistor Circuit

VDD 3 0 DC VDD
RL 3 4 LOAD
M1 4 1 2 2 NMOS
