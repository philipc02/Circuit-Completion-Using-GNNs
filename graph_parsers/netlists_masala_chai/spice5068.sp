plaintext
* Differential Amplifier Circuit

V1 3 0 AC 5mV
VCC 5 0 DC 12V
VEE 8 0 DC -12V

Q1 2 3 8 NPN
Q2 6 2 8 NPN

RC1 5 4 51k
RC2 5 6 51k

RB1 3 2 10k
RE 2 8 51k

* Define nodes:
* 1: Vout (-)
* 5: Vout (+)

.END
