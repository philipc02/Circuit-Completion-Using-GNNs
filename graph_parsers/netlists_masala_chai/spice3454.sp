spice
* SPICE netlist for the schematic
* Voltage Source
V1 6 10 DC Vin

* Current Sources
I1 6 7 DC 5nDg(amma)iD
I2 4 3 DC gm

* Resistors
R1 4 7 8nD
R2 8 3 8nL

* Output
Vout 8 2 DC Vout

* End of netlist
