plaintext
Vin 5 2 DC 0V
R1 5 3 1k
D1 3 2 D
.model D D
