plaintext
* NPN BJT Amplifier Circuit
VCC 4 0 DC 3
VEE 3 0 DC -3

RB 2 5 20k
RE 4 4 2.2k
RC 3 3 2.2k

Q1 3 2 4 NPN

VIN 2 0 DC 0

* Node Voltage
* Node 1 - Collector of Q1
* Node 2 - Base of Q1
* Node 3 - Emitter of Q1
* Node 4 - Connection to VCC
* Node 5 - Connection to Ground
