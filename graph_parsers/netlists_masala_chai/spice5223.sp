* SPICE Netlist
Vf 5 0 DC 0

* NPN Transistor
Q1 2 6 8 NPN

* Capacitors
C1 9 2
C2 3 3

* Inductor
L1 4 2

* Output
Vout 2 0

.model NPN NPN
.END
