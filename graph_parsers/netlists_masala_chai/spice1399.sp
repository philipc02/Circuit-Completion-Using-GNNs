* Components
MREF X VDD 0 0 NMOS
M1 0 X 0 0 NMOS

* Current Sources
IREF VDD 0 DC [value]

* Netlist descriptions
* MOSFET connections: Mname Drain Gate Source Body ModelName
* IREF is connected to VDD and has a reference node 0
