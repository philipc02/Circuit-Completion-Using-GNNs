* Transistor Definitions
M1 3 0 4 4 NMOS
M2 3 0 4 4 NMOS
M3 3 3 0 0 PMOS
M4 3 3 4 4 PMOS
M5 3 3 3 3 PMOS
M6 3 2 4 4 PMOS
M7 6 6 3 3 PMOS
M8 6 6 0 0 PMOS

* Current Source
I1 4 0 DC I_SS

* Resistors
R1 3 6 1k
R2 3 2 1k

* Voltage Sources
VDD 6 0 DC V_DD
Vin1 3 0 DC Vin1
Vin2 4 0 DC Vin2
Vb1 0 0 DC Vb1
Vb2 2 0 DC Vb2
Vb3 6 0 DC Vb3

.ends
