spice
* SPICE netlist for the given circuit

Iin 3 2 DC
VB 3 0 DC
D1 4 2 Dmodel
R1 4 2 1k

* Model for the diode
.model Dmodel D
