spice
Vin 4 3 DC 0V
R1 4 2 1k
D1 2 3 D_model
VB 2 3 DC 0V

.model D_model D
