plaintext
* NMOS Inverter
M1 4 2 3 3 NMOS
M2 2 3 0 0 NMOS
R1 4 2 1k
R2 3 0 1k
VDD 4 0 DC 5V
.model NMOS nmos (kp=60u Vto=1V)
