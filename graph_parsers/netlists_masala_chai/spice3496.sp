spice
* Transistors
Q1 5 4 10 QN
Q2 6 5 10 QP

* Resistors
RB11 4 6 1k
RB21 6 2 1k
RC1 4 5 1k
RB12 5 6 1k
RB22 6 8 1k
RC2 5 6 1k
RE1 10 3 1k
RE2 8 3 1k
RL 8 9 1k
RT 12 2 1k

* Capacitors
C1 12 2 10u
CE 10 3 10u
CO 9 3 10u
CP 8 3 10u

* Voltage Sources
VCC 4 0 DC 15V
VT 11 0 DC 5V

* End
