spice
* SPICE Netlist

* NMOS Transistor
M1 7 A 4 4 NMOS

* PMOS Transistor
M2 3 B 4 4 PMOS
M3 3 C 4 4 PMOS

* Power Supplies
VDD 3 0 DC 5V
VSS 0 0 DC 0V

* Output
Y 4 6

.end
