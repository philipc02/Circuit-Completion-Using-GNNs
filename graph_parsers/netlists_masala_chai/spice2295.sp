spice
* Components identified:
* D1, D2: Diodes
* R1: Resistor (1 kΩ)

Vin in 0 DC 0

D1 in out D
D2 out in D
R1 out 0 1k

.end
