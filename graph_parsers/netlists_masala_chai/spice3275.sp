spice
* Inductors
L1 7 3 LP
L2 5 4 LP

* Resistors
R1 3 4 RP
R2 5 4 RP

* Capacitors
C1 3 4 CP
C2 5 4 CP

* MOSFETs
M1 1 6 2 2 NMOS
M2 Y 5 2 2 NMOS

* Voltage Sources
VDD 4 0 DC VDD

* Output
Vout 4 9 DC 0

* End of Netlist
