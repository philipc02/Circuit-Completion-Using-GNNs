plaintext
* SPICE Netlist

Vplus 7 0 DC 10.7
Vi 6 0
I1 1 0 DC 1m
I2 2 5 DC 5m

Rin 6 2 10k
R2 2 5 9k
R1 2 0 1k
Rout 5 3 2k
R3 3 7 20k

Q1 3 2 1 NPN
Q2 4 2 3 NPN
Q3 5 2 3 NPN

.END
