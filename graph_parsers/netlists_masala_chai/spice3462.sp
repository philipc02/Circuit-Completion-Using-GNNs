plaintext
VDD 4 0 DC VDD

I_GS1 7 1 DC VGS1
I_GS2 5 2 DC VGS2
I_BIAS 3 0 DC IBIAS

RD1 7 4 RD
RD2 5 4 RD
