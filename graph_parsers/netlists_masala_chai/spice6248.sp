spice
* SPICE netlist for the circuit

Q13A 7 3 1 NPN
Q14 7 5 8 NPN
Q19 3 2 2 NPN
Q18 3 2 4 NPN
Q20 8 4 6 NPN
Q23 4 9 10 NPN

R10 2 9 40k

VCC 5 7 DC <VCC>
VEE 10 6 DC <VEE>

* End of netlist
