spice
* NMOS Transistors
M1 2 8 10 10 NMOS
M2 7 5 10 10 NMOS

* PMOS Transistors
M3 2 3 9 9 PMOS
M4 7 3 9 9 PMOS

* Current Source
Iss 10 8 DC

* Power Supply
VDD 9 8 DC

* Node Mapping
* 1: VDD
* 2: Vout
* 3: Common Gate for PMOS (M4/M3)
* 5: Gate of M2
* 7: Common Drain for M1 and M2
* 8: Vin
* 9: Power Supply
* 10: Ground
