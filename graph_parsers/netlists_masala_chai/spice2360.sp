* NMOS Transistors
M1 4 5 7 7 NMOS
M2 4 6 9 9 NMOS
M3 24 42 42 42 NMOS
M4 26 42 42 42 NMOS
M5 42 25 24 24 NMOS
M6 42 25 26 26 NMOS
MB1 7 1 3 3 NMOS
MB2 22 23 42 42 NMOS

* PMOS Transistors
M7 2 21 3 3 PMOS
M8 2 21 22 22 PMOS
M9 2 8 2 2 PMOS
M10 33 8 2 2 PMOS
MU1 2 22 23 23 PMOS
MU2 2 22 2 2 PMOS

* Voltage Sources
VDD 2 0 DC
VSS 42 0 DC
VIN+ 4 0 DC
VIN- 4 0 DC
VBIAS3 8 0 DC
VBIAS4 7 0 DC
VBIAS5 25 0 DC
VBIAS6 21 0 DC
VCMFB 24 0 DC
