* SPICE Netlist

* Voltage Sources
VDD 4 0 DC <value>
Vb 3 0 DC <value>
Vin 1 0 DC <value>

* PMOS Transistor
M2 2 3 4 4 PMOS_MODEL

* NMOS Transistor
M1 2 1 0 0 NMOS_MODEL

* Resistor
RD 4 2 <value>

* Output
Vout 2 0

* End of Netlist
