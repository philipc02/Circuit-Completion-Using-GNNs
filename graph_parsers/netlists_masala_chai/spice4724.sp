* SPICE Netlist for the given circuit
V1 6 0 DC 15V
V2 3 2 DC 15V
R1 6 5 RB
R2 4 3 3k
Q1 4 5 7 NPN
