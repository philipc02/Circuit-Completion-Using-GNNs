spice
* NMOS Transistor M1
M1 3 1 2 2 NMOS

* Voltage Source Vx
Vx 3 0 DC 0

* Current Source Ix
Ix 3 2 DC 0

* Supply Voltage
VDD 1 0 DC 1.8V

* End of Netlist
.end
