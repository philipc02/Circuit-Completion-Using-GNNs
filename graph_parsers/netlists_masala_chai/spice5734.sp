spice
* PMOS Transistor (MP1)
MP1 5 4 3 3 PMOS W=9u

* NMOS Transistor (MN1)
MN1 2 4 3 3 NMOS

* Voltage Source (V1)
V1 5 2 DC 3V

* Current Source (I1)
I1 2 3 DC I6

* Ground
V0 3 0 DC 0V

.END
