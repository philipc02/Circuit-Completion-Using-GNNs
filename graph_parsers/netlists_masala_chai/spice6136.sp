spice
* SPICE Netlist for the given circuit

* Voltage Controlled Current Source
G1 5 4 4 2 gm

* Resistor
RL 4 2 RL

* Capacitor Cμ
Cμ 4 3 Cμ

* Capacitor C2
C2 4 6 C2

* Define ground
V0 3 0 0
