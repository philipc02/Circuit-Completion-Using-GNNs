spice
* SPICE Netlist

VA 2 0 DC 0
IA 2 2 DC 0
D1 2 3 DModel
D2 3 22 DModel

.model DModel D
