* SPICE netlist for the circuit

Vin 3 5 DC <Voltage_Value_for_Vin>
D1 2 3 Dmodel
R1 2 4 <Resistance_Value_R1>
Vb 4 5 DC <Voltage_Value_for_Vb>

.model Dmodel D
