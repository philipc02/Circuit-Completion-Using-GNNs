spice
* SPICE Netlist
R1 2 3 R1_value
R2 2 3 R2_value
R3 3 5 R3_value
R4 6 4 R4_value
