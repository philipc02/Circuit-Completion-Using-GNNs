* SPICE Netlist for the given circuit

V_in 6 0 DC 0
R_rpi 2 5 r_pi
I_i1 5 4 DC 0
G_gm 0 4 5 0 gm
R_RL 4 3 R_L
V_out 3 0 DC 0
