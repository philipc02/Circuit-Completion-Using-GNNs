spice
* SPICE Netlist

D1 2 0 D_MODEL
Q1 6 2 3 QN_MODEL

.model D_MODEL D
.model QN_MODEL NPN

.END
