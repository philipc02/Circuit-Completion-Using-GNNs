spice
I1 3 0 DC VBIAS

M1 5 2 4 4 NMOS_MODEL
M2 3 3 2 2 NMOS_MODEL
