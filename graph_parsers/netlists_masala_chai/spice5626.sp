spice
V1 1 0 DC vI
R1 1 4 R
D1 4 3 D1_model
D2 4 2 D2_model
V2 4 0 DC vO

.model D1_model D
.model D2_model D
