spice
* SPICE netlist for the given schematic

VEB 2 3 DC 0
VBC 3 4 DC 0

Q1 2 3 4 NPN

*.model NPN NPN (parameters if available)
.end
