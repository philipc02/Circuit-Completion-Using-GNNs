spice
* SPICE Netlist

* Voltage Source
VDD 3 0 DC VDD

* NMOS Transistor
M1 3 VIN VF VF NMOS

* Resistor
RD 3 VDD RD

* Capacitors
C1 VOUT 2 C1
C2 VF 0 C2

* End of Netlist
