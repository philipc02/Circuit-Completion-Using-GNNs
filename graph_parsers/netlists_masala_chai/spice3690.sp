plaintext
* NMOS Amplifier Circuit

V1 5 4 DC 0V
VDD 6 4 DC VDD
M1 3 5 4 4 NMOS_MODEL
RD 6 3 RD_VALUE

* End of Netlist
