* Voltage Sources
V1 4 0 DC vI1
V2 9 0 DC vI2
V3 8 0 DC vI3
V4 7 0 DC vI4

* Resistors
R1 4 2 R1
R2 9 2 R2
RA 8 3 RA
RB 7 3 RB
RC 3 0 RC
RF 2 6 RF

* Operational Amplifier
* Note: The Op-Amp model should be defined before using it in actual simulations.
XU1 2 3 6 OPAMP

* Output Voltage
VOUT 6 0 DC 0

.END
