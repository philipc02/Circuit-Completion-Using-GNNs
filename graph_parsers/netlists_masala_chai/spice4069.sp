spice
* BJT Amplifier Circuit

* Voltage Sources
Vi 10 0 DC 0

* Resistors
R1 3 6 R1_value
R2 6 5 R2_value
RC 3 11 RC_value
RE 5 8 RE_value
RS 10 1 RS_value
RL 11 2 RL_value

* Capacitors
CC 1 6 CC_value
CE 5 2 CE_value
CL 11 2 CL_value

* NPN Transistor
Q1 11 6 5 NPN

* Power Supply
V+ 3 0 DC Vplus_value
V- 8 0 DC Vminus_value

* Ends
