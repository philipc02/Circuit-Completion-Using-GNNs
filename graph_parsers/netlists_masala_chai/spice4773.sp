plaintext
* PNP Transistor Circuit

VEE 1 0 DC 10V
R1 2 0 10k
R2 3 2 2.2k
RE 1 5 1k
RC 5 0 3.6k
Q1 5 2 3 3 2N3906

.model 2N3906 PNP
.end
