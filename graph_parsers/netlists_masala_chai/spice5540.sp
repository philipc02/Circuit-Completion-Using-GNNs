spice
* Netlist for the given circuit
V1 6 7 DC 10V
R1 6 2 2k
R2 4 4 1k
