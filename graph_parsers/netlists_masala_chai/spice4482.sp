spice
* SPICE Netlist

V1 6 3 DC V_L
R1 1 5 R_1
Rif 1 2 R_if
R2 2 0 R_2
RL 2 4 R_L
* Operational amplifier connection
* Ideal op-amp model not directly defined, typically used with a .subckt or predefined model

* .end to end the netlist
