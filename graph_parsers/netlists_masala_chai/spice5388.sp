spice
* SPICE Netlist
Vs 4 5 AC 1
R1 4 2 1k
C1 2 3 0.01uF
