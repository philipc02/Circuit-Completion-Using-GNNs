plaintext
* BJT Circuit
VBB 4 0 DC <value_for_VBB>
VCE 2 0 DC <value_for_VCE>
RB 4 4 4 <value_for_RB>
Q1 2 4 3 QMODEL

.model QMODEL NPN (BF=100)
