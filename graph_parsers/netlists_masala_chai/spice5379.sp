spice
* Components
C1 5 2 0.1uF
C2 2 3 0.47uF
C3 3 6 0.22uF
VS 5 7 DC 25V
* Connections to ground
VSS 7 6 DC 0V
