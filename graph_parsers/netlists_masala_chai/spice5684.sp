* Nodes
* 2 3 4 5 6 7 8

* Components
* NMOS Transistor
M1 4 3 2 2 NMOS

* Voltage Sources
VSG 5 2 DC
VSD 6 7 DC

* Current Source
I1 8 2 DC

.END
