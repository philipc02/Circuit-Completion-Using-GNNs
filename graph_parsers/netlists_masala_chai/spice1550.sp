spice
* Differential Amplifier Circuit

Q1 2 4 5 NPN
Q2 3 2 5 NPN

R1 1 3 RC/2
R2 5 0 REE

V1 1 0 VCC
V2 4 0 VCM

I1 5 0 IEE

.end
