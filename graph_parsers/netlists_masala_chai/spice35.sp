spice
* SPICE netlist for the given schematic

VCC 1 2 DC VCC
VS 6 0 DC VS
VBIAS 6 0 DC VBIAS

RS 5 6 20k
RC 2 2 5k
RL 2 3 10k

Q1 2 5 4 NPN

.END
