spice
* Differential pair with resistive load
*------------------------------------------------
RD1 3 6 RD
RD2 4 5 RD
Ron3 5 0 Ron3
M1 6 2 5 5 NMOS
M2 5 2 4 4 NMOS
VDD 2 0 DC VDD
*------------------------------------------------
