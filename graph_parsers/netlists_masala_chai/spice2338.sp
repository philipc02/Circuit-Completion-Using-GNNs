M1 10 2 9 9 NMOS
M2 8 2 6 6 NMOS
M3 3 4 4 4 PMOS
M4 5 4 4 4 PMOS
I1 4 0 DC I
I2 4 0 DC I
VBIAS 2 0 DC VBIAS
