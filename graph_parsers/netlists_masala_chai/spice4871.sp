spice
* SPICE Netlist
VCC 12 0 DC VCC
VIN 6 0 AC VIN

C1 6 2 C1_VALUE
C2 8 9 C2_VALUE

R_E 5 8 RE_VALUE
R_C 3 12 RC_VALUE
R1 4 3 R1_VALUE
R2 4 9 R2_VALUE

Q1 3 4 5 NPN_MODEL

.END
