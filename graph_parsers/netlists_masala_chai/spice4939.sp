plaintext
* NMOS Common Source Amplifier

VDD 7 0 DC 30V

R1 7 5 2MEG
R2 5 0 1MEG
RD 7 6 1K
RS 3 4 2K

M1 6 5 3 3 NMOS

* Model Parameters for NMOS
.model NMOS NMOS(Level=1)

.end
