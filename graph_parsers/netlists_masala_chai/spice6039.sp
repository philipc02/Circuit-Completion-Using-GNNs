spice
* SPICE Netlist

** NMOS Transistors
M1 3 6 4 4 NMOS
M2 7 2 4 4 NMOS

** PMOS Transistors
M3 3 5 5 5 PMOS
M4 4 4 5 5 PMOS

** Resistors
R1 4 8 RSS

** Voltage Sources (considered as signal input)
V1 6 0 vicm
V2 2 0 vicm

** End of Netlist
