spice
* Diode OR Circuit
D1 2 1 D
D2 2 3 D
RL 2 0 1000
VA 1 0 DC 5V
VB 3 0 DC 5V

.MODEL D D

.END
