plaintext
* PMOS Transistor
M1 2 6 5 5 PMOS

* Voltage Source
VDD 2 5 DC VDD_VALUE

* Model Definition
.model PMOS PMOS (LEVEL=1 VTO=-0.7 KP=30u)

* End
