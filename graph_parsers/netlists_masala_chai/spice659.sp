spice
* SPICE Netlist
* Voltage Source
V1 2 0 DC Vin

* Capacitors
C1 2 3 C1
C2 3 4 C2

* Ground
V0 4 0 DC 0
