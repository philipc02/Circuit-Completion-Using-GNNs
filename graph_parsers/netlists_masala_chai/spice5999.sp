spice
* SPICE Netlist

* Voltage Source
Vsig 7 8 DC 0

* Current Source
I1 3 4 DC 0.5mA

* Resistors
R1 4 2 10k
R2 7 6 10k

* NPN Transistors
Q1 5 6 3 NPN
Q2 2 3 3 NPN

* End of Netlist
