* Netlist for the schematic

M1 2 3 3 3 NMOS
I_BIAS 3 2 DC 0.002A
V_BIAS 2 0 DC 1V

.model NMOS NMOS
