spice
* NMOS Transistor
M1 7 3 2 2 NMOS

* Current Source
I1 2 4 IX

* Voltage Source
V1 4 2 VX

.model NMOS NMOS
