plaintext
* SPICE Netlist
V1 4 0 DC 3.0V
R1 4 2 39
L1 2 3 82u
C1 4 3 1.5n
.END
