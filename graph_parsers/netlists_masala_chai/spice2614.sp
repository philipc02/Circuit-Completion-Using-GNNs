plaintext
* MOSFET Differential Pair Circuit

VDD 5 0 DC VDD
Vin 9 0 DC Vin

* Resistors
RD1 5 2 RD
RD2 8 2 RD

* NMOS Transistors
M1 2 9 4 4 NMOS
M2 2 6 4 4 NMOS

* Current Source
I1 3 7 DC Icont1

* Connections
Vcont1 3 0 DC Vcont1

.END
