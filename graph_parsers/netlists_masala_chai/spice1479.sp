plaintext
* Transistor Definitions
M1 2 3 0 0 NMOS
M2 1 4 0 0 NMOS
M3 2 4 2 2 PMOS
M4 4 4 2 2 PMOS
M5 2 0 0 0 NMOS
M_REF 5 0 0 0 NMOS

* Current Source
I_REF 5 4 DC 1.8mA

* Voltage Source
VDD 4 0 DC 1.8V

* Nodes
* Node 0 is ground
* Node 1 is Vin
* Node 2 is Vout
* Node 3 is Vb
