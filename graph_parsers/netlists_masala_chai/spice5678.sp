* SPICE Netlist
C1 vI 2 C_value
D1 2 2 D_model
R1 2 3 R_value
.end
