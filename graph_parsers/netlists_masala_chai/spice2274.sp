spice
* SPICE Netlist for the circuit

VDD 3 0 DC 1.8V
I1 3 4 DC 1mA
R1 1 2 1k
R2 4 3 10k
C1 0 1 1uF
M1 4 2 0 0 NMOS

* Connections:
* V_in connects to the left side of C1
* VIN 0 1

.end
