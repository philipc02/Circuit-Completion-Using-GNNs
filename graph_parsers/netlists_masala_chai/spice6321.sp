spice
* SPICE Netlist for Provided Schematic

M1 6 5 6 6 PMOS
M2 3 2 7 7 NMOS
Q1 6 8 3 NPN
Q2 3 2 0 NPN
VDD 6 0 DC VDD
VIN 5 0 DC VI

* End of Netlist
