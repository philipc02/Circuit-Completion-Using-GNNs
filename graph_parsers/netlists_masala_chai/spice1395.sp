* Circuit Netlist
M1 3 2 4 4 PMOS
M2 vout 2 4 4 PMOS
M3 2 5 0 0 NMOS
I1 3 0 DC I_REF

* Voltage Nodes
VCC 4 0 DC
Vin 5 0 DC

.END
