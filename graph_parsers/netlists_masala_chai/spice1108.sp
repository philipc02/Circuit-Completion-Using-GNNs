* Netlist for the given schematic

M1 drain gate source NMOS

VDD VDD 0 DC 5V
RD drain VDD 1k

* Connecting nodes
* Assuming nodes based on schematic:
* gate is connected to node where RD and VDD meet.
* VDD is the positive terminal of voltage source.
* Source is connected to ground (0).

.END
