spice
* Voltage Source
Vin 2 0 AC 1

* Operational Amplifier
* Note: Op-Amp is often specified in sub-circuits, placeholder for model here.
XU1 2 3 2 opampmodel

* Model Definitions (Placeholder for actual opamp model which isn't specified)
.model opampmodel opamp
