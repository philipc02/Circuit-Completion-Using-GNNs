plaintext
* SPICE Netlist for the provided schematic

Vin in 0 DC 0
D1 in 2 Dmodel
D2 2 out Dmodel
RL 2 out 1000
.model Dmodel D

.end
