spice
* Differential Amplifier

Q1 6 7 1 NPN
Q2 4 2 3 NPN

RC1 5 7 1k
RC2 5 2 1k
REE 1 3 1k

V1 6 0 DC 0.5
V2 4 0 DC 0.5

VOD 5 22 DC 0
VEE 3 0 DC 0

.END
