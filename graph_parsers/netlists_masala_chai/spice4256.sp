* SPICE Netlist for the Circuit

* NMOS Transistor
M0 2 1 2 2 NMOS

* PMOS Transistors
M1 3 4 5 5 PMOS
M2 3 3 5 5 PMOS

* Capacitor
CC 2 3 VALUE

* Resistor
RL 3 0 VALUE

* Current Source
IREF 3 2 DC VALUE

* Voltage Input
Vin 1 0 DC VALUE

* Voltage Supply
V+ 5 0 DC VALUE

.END
