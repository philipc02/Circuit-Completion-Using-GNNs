spice
* SPICE Netlist for the given schematic
* Nodes: 1, 2, 3, 4, 0 (Ground)

VDD 1 0 DC {VDD}

RD 1 2 {RD}

Inin 4 0 DC {I_in}

C_in 3 0 {C_in}

M1 1 3 4 4 NMOS
