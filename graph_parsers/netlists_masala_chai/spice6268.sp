plaintext
* Transistors
Q1 2 7 4 NPN
Q2 4 4 3 NPN
Q3 1 2 2 NPN
Q4 5 2 3 PNP

* Current Source
I1 2 7 DC <Current Value>

* Voltage Sources
VCC 1 0 DC 15
VEE 3 0 DC -15

* Ground
RGROUND 8 0 0.001
