* NPN Transistor Amplifier
VCC Vcc 0 2.5V
Vin Vin 0

* Transistor
Q1 Vcc Vin Vout NPN

* Resistor
RE Vout 0 RE

.model NPN NPN
