spice
* Transistor
Q1 2 4 5 NPN

* Resistors
RC 2 3 5k
RB 4 3 150k

* Voltage Sources
V1 3 0 1.3
V2 2 0 5

* Voltage Input
VIN 4 3

* Model Definitions
.model NPN NPN
