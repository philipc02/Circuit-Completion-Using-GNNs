plaintext
* SPICE Netlist for Given Schematic
R1 A 3 R1
R2 3 5 R2
R3 5 2 R3
R4 2 4 R4
R5 B 4 R5

.END
