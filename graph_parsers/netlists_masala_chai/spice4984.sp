plaintext
* NMOS Circuit
M1 2 1 3 3 NMOS
RD 4 2 1k
VDD 4 0 DC 10V
VIN 1 0 AC 1V
* Model Definitions
.model NMOS NMOS (KP=100u VTO=1V)
