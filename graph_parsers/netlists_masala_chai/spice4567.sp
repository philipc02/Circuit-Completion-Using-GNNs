spice
* SPICE Netlist for CMOS Logic Circuit

* PMOS Transistors
M1 3 1 7 7 PMOS
M2 3 2 7 7 PMOS

* NMOS Transistors
M3 4 1 8 8 NMOS
M4 4 2 8 8 NMOS

* Voltage Sources
VDD 7 0 DC V+

* Connectivity
X1 1 2 3 4

* Ground
R1 8 0 0

* End of Netlist
