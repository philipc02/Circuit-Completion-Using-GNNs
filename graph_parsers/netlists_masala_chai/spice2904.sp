spice
* SPICE netlist for the given circuit
M1 2 1 0 0 NMOS
M2 4 1 3 3 PMOS
RD 3 2 RD_VALUE
RG 1 0 RG_VALUE
VDD 3 0 DC VDD_VALUE
Vin 1 0 DC VIN_VALUE
.end
