plaintext
* BJT Transistors
Q1 3 8 9 NPN
Q2 3 8 6 NPN
Q3 9 2 10 NPN
Q4 6 7 10 NPN
Q5 7 2 9 NPN
QC 2 3 1 NPN
QD 1 2 3 NPN
QA 4 2 5 NPN
QB 5 2 10 NPN

* Resistors
R1 5 9 1k
R2 8 6 1k
R3 6 8 1k
R4 1 3 1k
RS 7 2 1k
RREF 4 5 1k

* Voltage Sources
V+ 1 0 DC 15V
V- 10 0 DC -15V

* End of netlist
