spice
* Netlist for the given schematic
R1 1 2  [Resistance_value1]
R2 2 3  [Resistance_value2]
M1 3 2 0 0 NMOS
