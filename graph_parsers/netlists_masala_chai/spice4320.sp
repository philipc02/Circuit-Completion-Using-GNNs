spice
* NMOS Transistors
M1 5 2 0 0 NMOS
M2 3 4 5 5 NMOS

* Define Models (Ensure to define these in your simulation software)
.model NMOS NMOS
