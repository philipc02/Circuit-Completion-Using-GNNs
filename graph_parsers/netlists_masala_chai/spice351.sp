spice
* SPICE Netlist

V1 4 2 DC 0
R1 4 2 R1_value
R11a 2 3 R11a_value
R22a 2 3 R22a_value
R11f 2 6 R11f_value
R22f 2 6 R22f_value
RL 2 7 RL_value

I1a 2 3 DC I1a_value
I2a 2 3 DC I2a_value
I1f 2 6 DC I1f_value
I2f 2 6 DC I2f_value

Vs 2 4 DC Vs_value

.END
