spice
* SPICE Netlist
* Voltage Source
V1 4 0 DC 18

* Resistors
RS 4 3 270
RL 3 2 1k

* Diode
D1 3 2 D

.model D D
