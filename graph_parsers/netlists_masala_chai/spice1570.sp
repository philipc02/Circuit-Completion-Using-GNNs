spice
M1 3 1 2 2 NMOS
RS 3 0 1k
VDD 2 0 DC 5V
VIN 1 0 DC 1V
