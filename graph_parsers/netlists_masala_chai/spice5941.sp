* SPICE Netlist for the given schematic

Q1 6 7 2 NPN
Q2 3 2 5 NPN
I1 2 0 DC <Current_Value_I1>
I2 4 3 DC <Current_Value_I2>
