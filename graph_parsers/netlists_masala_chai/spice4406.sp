spice
* Transistors
Q1 6 5 7 NPN
Q2 4 3 7 NPN

* Resistors
R1 5 6 80k
R2 6 2 20k
R3 4 3 85k
R4 3 2 15k
RC1 7 8 2k
RC2 7 4 4k
RE1 2 0 1k
RE2 2 0 0.5k
RF 2 3 10k
RL 3 0 4k

* Capacitors
C1 5 0 C1_value
C2 6 2 C2_value
C3 3 0 C3_value
CE1 2 0 CE1_value
CF 2 3 CF_value

* Current Source
I1 5 0 DC ii_value

* Voltage Source
V1 8 0 DC 10V

.end
