plaintext
* SPICE Netlist for the given circuit

VCC 5 0 DC VCC
VEE 0 22 DC VEE
RC 5 22 RC
RB 3 6 RB
RE 4 22 RE
Q1 22 3 4 NPN

.model NPN NPN
.end
