spice
* Op-Amp Configuration
XOPAMP 0 X Vout OPAMP1

* Components
R1 Vin X 1k
CF X Vout 1u

* Voltage Source
Vin Vin 0 DC 1

* Control Statements
.op
.end
