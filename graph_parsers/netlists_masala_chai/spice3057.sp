plaintext
* NMOS Transistors
M1 5 2 1 1 NMOS
M2 2 2 1 1 NMOS
M3 3 4 1 1 NMOS
M4 4 2 1 1 NMOS

* PMOS Current Source
M_CM 2 2 3 3 PMOS

* Current Sources
I1 1 0 DC
I2 6 0 DC

* Nodes
* Node 1: Ground connection for current sources
* Node 2: Vb (common gate for M2 and M4)
* Node 3: Positive supply (upper side)
* Node 4: Vout2
* Node 5: Vout1
* Node 6: Ground connection for right current source
