spice
* Circuit Netlist

* Voltage Sources
Vx1 9 1 DC Vx1_value
Vy1 8 1 DC Vy1_value
Vx2 10 2 DC Vx2_value
Vy2 11 2 DC Vy2_value

* Current Sources
Ix1 2 6 DC I_x3_value
Ix2 4 3 DC I_x4_value
I1 5 7 DC I1_value

* Resistors
Rx1 9 8 R_x1_value
Rx2 10 11 R_x2_value
Rx3 6 7 R_out_a_value
Rx4 4 5 R_x4_value
Rt 1 3 R_out_b_value
Rtail 7 1 R_tail_value

* End of Netlist
