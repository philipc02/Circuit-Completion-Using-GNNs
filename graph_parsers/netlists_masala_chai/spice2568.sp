plaintext
* NMOS Common-Source Amplifier

M1 4 1 3 3 NMOS
RD 5 4  RD_VALUE
VDD 7 5 DC VDD_VALUE
VOUT 2 4

* Model Declaration
.model NMOS NMOS_MODEL

* End of Netlist
