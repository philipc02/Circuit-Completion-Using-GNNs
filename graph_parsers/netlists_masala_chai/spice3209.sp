spice
* SPICE Netlist for given schematic

M1 Vout CK N001 N001 NMOS_MODEL
ID1 N001 0 DC IValue
VDD N002 0 DC VValue
CH Vout N002 CHValue

*.model lines and other parameters can be specified as per requirements
