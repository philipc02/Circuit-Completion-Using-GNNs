spice
* SPICE Netlist
* Components
M1 2 1 0 0 NMOS
CGS1 5 2 CVALUE_GS
CGD1 2 4 CVALUE_GD
CDB1 2 3 CVALUE_DB
CSB1 3 0 CVALUE_SB
RS 5 2 RVALUE_S
RD 4 2 RVALUE_D
VDD 4 0 DC VVALUE_DD
Vin1 5 0 DC VVALUE_IN AC VAMPLITUDE

* Models
.model NMOS NMOS (LEVEL=1)
