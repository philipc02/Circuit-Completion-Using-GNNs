plaintext
* Nodes are indicated by numbers in the annotated image.

M1 2 1 7 7 NMOS
M2 3 6 7 7 NMOS
M3 2 4 2 2 PMOS
M4 3 5 2 2 PMOS
M5 4 2 3 3 PMOS
M6 5 3 3 3 PMOS
M7 4 2 2 2 PMOS
M8 5 2 2 2 PMOS

VDD 2 0 DC 5
VIN 1 0 DC 0
VB 6 0 DC 0
ISS 7 0 DC 0.1

* End of SPICE netlist
