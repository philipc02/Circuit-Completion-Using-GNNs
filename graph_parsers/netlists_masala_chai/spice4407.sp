plaintext
* SPICE Netlist

* Current Sources
I_i 8 2 DC 0
I_e 2 9 DC 0

* Transistors
Q1 4 6 9 NPN
Q2 5 4 9 NPN

* Resistors
R5 2 8 R5_value
RB1 6 9 RB1_value
RC1 2 4 RC1_value
RB2 2 5 RB2_value
RE2 5 9 RE2_value
RC2 2 5 RC2_value
RL 2 3 RL_value
RF 9 3 RF_value

* Control
V1 9 3 DC 0

* End of Netlist
