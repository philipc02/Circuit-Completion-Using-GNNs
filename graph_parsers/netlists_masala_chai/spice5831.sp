* SPICE Netlist

V1 2 0 DC 1
Rsig 2 3 1MEG
RL 4 0 1K

* Connections
* V1 connected between node 2 and ground
* Rsig connected between node 2 and node 3
* RL connected between node 4 and ground

.END
