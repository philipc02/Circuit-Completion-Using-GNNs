plaintext
Vx 5 3 DC
Ix 5 4 DC 0A
R1 4 2 1k
D1 2 0 Ideal
Vb 2 3 DC
