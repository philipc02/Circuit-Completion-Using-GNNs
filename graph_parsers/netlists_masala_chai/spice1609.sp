plaintext
* Differential Amplifier Circuit

V_CM 3 0 DC <value>
V_CC 4 0 DC <value>

I_EE 5 0 DC <value>

Q1 3 3 5 NPN
Q2 3 3 5 NPN
Q3 3 2 0 NPN

RC1 4 3 <value>
RC2 4 3 <value>

* Define model for NPN (using default if not provided)

.model NPN NPN
