spice
* SPICE netlist for the given circuit

R1 6 3 1k
R2 3 5 1k
R3 7 3 1k
R4 3 2 1k
R5 3 4 1k

V1 7 2 DC 0

* End of netlist
