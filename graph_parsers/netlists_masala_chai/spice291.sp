plaintext
* SPICE Netlist for the given schematic

Vi 6 7 DC 0
RS 6 3 100k
Rb 3 4 50k
Cpi 3 3 10p
Cmu 3 5 1p
Gm 3 2 POLY(2) (1 0) 0.01
RL 5 2 1k
Vo 5 2 DC 0

.END
