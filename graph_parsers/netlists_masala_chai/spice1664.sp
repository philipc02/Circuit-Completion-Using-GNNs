plaintext
* NMOS transistor
M1 2 3 6 6 NMOS

* Capacitors
C_GD 2 3 C_GD_value
C_GS 3 5 C_GS_value
C_DB 2 4 C_DB_value
C_SB 6 4 C_SB_value

* Resistor
R_L 2 V_DD R_L_value

* Voltage Sources
V1 5 0 V_in_value
V2 V_DD 0 V_DD_value

* End of netlist
