spice
* Sample SPICE Netlist

Vsig 3 0 DC 0
Rsig 3 4 1k
Q1 5 4 2 NPN
Re 2 6 1k
RL 2 0 1k

* Power Supply
Vcc 5 0 DC 15

.end
