plaintext
* SPICE Netlist for the Given Circuit

* Voltage Source
V1 3 0 DC VIN

* Resistors
R1_1 4 5 R1
R1_2 4 2 R1
RL 2 6 RL

* Current Source
I1 3 5 DC I1

* Voltage Rails
VCC 5 0 DC +12V
VEE 3 0 DC -12V

* End of netlist
