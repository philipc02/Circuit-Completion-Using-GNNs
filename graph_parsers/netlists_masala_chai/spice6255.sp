spice
* SPICE Netlist
Vt 6 3 DC

R10 4 7 40k

* Transistors
Q19 5 8 4 NPN
Q18 5 2 4 NPN

* Node Voltage or Current Reference
V_ref 6 0 DC 0

.end
