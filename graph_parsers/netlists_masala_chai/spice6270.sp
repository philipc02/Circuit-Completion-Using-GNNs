plaintext
* SPICE Netlist

Q1 5 3 2 NPN
R1 3 4 1k
R2 6 3 1k
I1 5 4 DC 180u

* Models
.model NPN NPN (IS=1E-14 BF=100)
