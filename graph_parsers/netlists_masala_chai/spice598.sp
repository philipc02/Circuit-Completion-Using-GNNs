spice
* SPICE Netlist

* Voltage Source
V1 2 3 DC V_X

* Current Source
I1 2 3 DC I_X

* Resistor
R1 2 3 R1

* Diode
D1 2 3 D1_model

* Diode Model
.model D1_model D
