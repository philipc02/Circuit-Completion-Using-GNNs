VB 4 2 DC 0
D1 3 2 D_model
D2 3 2 D_model
ITOT 4 3 DC 0

.model D_model D
