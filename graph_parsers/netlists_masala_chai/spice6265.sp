* Transistors
Q1 5 1 0 NPN
Q2 5 5 0 NPN
QP 5 5 4 PNP
QN 3 2 5 NPN

* Current Sources
I1 1 5 DC [VALUE_OF_CURRENT]
I2 2 3 DC [VALUE_OF_CURRENT]

* Voltage Source
VCC 5 0 DC [VALUE_OF_VCC]

* End of netlist
