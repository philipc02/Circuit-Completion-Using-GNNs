spice
* NMOS Transistor
M1 4 3 0 0 NMOS

* Current Source
I1 2 4 DC 1mA

* DC Supply
VCC 2 0 DC 5V

* Analysis
.OP
.END
