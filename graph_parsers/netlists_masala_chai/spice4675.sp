spice
* SPICE Netlist for Diode-Rectifier Circuit

V1 3 0 AC
D1 3 2 IdealDiode
R1 2 0 1k

.model IdealDiode D

.end
