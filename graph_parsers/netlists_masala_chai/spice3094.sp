spice
* NMOS transistors: M1 through M6, M9, M10
* PMOS transistors: M7, M8, M11, M12

M1 5 4 9 9 NMOS
M2 5 2 9 9 NMOS
M3 2 5 6 6 NMOS
M4 6 5 2 2 NMOS
M5 8 2 7 7 NMOS
M6 6 2 7 7 NMOS
M9 1 8 7 7 NMOS
M10 2 6 7 7 NMOS

M7 7 1 9 9 PMOS
M8 7 6 2 2 PMOS
M11 8 7 9 9 PMOS
M12 3 7 2 2 PMOS

I1 9 0 DC 1A

VDD 7 0 DC 5V

* Nodes:
* 1 = Vin, 2 = Vb, 3 = Vout2, 4 = X, 5 = Y, 6 = Vout1
