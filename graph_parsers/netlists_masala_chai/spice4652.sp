spice
* SPICE Netlist
V1 5 7 AC 1        ; AC voltage source Vin
L1 5 6 1mH         ; Inductor L with value 1mH
C1 6 3 1uF         ; Capacitor C with value 1uF
R1 6 4 1k          ; Resistor RL with value 1kOhm
