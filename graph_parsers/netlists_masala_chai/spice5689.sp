* Nodes identified from the annotated image
* Components: NMOS (Q1), PMOS (Q2)

M1 2 3 4 4 NMOS
M2 2 6 5 5 PMOS

R1 3 5 R
R2 6 2 R2

VDD 5 0 DC 1.8

* Connections
* Q1: Drain (2), Gate (3), Source (4)
* Q2: Drain (2), Gate (6), Source (5)
