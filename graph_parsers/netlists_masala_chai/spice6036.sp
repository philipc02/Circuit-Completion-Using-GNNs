plaintext
* Differential Amplifier

Q1 6 8 7 QNPN
Q2 6 3 7 QNPN
Q3 5 4 6 QPNP
Q4 5 2 6 QPNP

I1 7 0 DC I

VCC 5 0 DC VCC
VEE 0 7 DC VEE

.model QNPN NPN
.model QPNP PNP

.end
