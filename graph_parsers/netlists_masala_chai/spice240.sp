plaintext
* NMOS Transistors
M1 1 2 7 7 NMOS
M1A 7 6 3 3 NMOS

* Voltage Sources
V1 2 0 DC Vi_AC vi
VBIAS 6 0 DC VBIAS

* Resistor
R1 3 0 R

* Ground
VSS 0 0 DC 0

* Output
VO 1 55

* End of Netlist
