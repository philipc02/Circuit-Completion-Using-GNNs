spice
V1 7 5 DC 1
RT 7 1 R
RG 6 4 R
RD 3 2 R
Cg1 4 2 C
Cgs1 6 2 C
Cpd2 2 2 C
Cgs2 2 3 C
Gm1 3 5 VOL=gm1*v(pi1)
Gm2 2 3 VOL=gm2*v(pi2)
