plaintext
* SPICE netlist for the provided schematic

* Resistors
R1 1 2 R
R2 2 2 R
R3 2 2 R
R4 2 2 R
R5 2 0 R

* Capacitors
C1 2 2 C
C2 2 3 C

* Diodes
D1 5 0 D
D2 3 0 D

* Operational Amplifiers
* Assuming op-amps are ideal
A1 2 3 0 4
A2 2 4 2 2

* Voltage Inputs
V1 1 0
V2 5 0

.end
