spice
* NMOS Diode-Connected Circuit
M1 1 1 2 2 NMOS
R1 2 0 1k
V1 1 0 DC 1.8
.model NMOS NMOS(Level=1)
.end
