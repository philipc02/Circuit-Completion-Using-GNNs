plaintext
* SPICE Netlist
L1 5 7 L
C1 2 7 C1
C2 5 2 C2
I1 2 0 DC I
R1 2 2 RL
M1 5 6 2 2 NMOS
