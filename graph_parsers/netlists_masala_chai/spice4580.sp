spice
* PMOS Transistors
M_P1 3 8 2 2 PMOS
M_P2 5 3 2 2 PMOS
M_P3 5 2 2 2 PMOS
M_P4 6 5 2 2 PMOS
M_P5 7 5 2 2 PMOS

* NMOS Transistors
M_N1 9 8 4 4 NMOS
M_N2 5 9 4 4 NMOS
M_N3 4 2 6 6 NMOS
M_N4 2 2 6 6 NMOS
M_N5 2 2 6 6 NMOS

* Voltage Supplies
VDD 2 0 DC 5V
VIN_Y 8 0
VIN_X 8 0

* Connections
VOUT_Z 7 0

* End of Netlist
