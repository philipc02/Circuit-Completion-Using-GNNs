spice
* NMOS Amplifier Circuit

M1 2 1 3 3 NMOS
R1 2 0 1k
V1 3 0 DC 1

* Voltage source Vin
Vin 1 0 DC

.model NMOS NMOS (Level=1)

.end
