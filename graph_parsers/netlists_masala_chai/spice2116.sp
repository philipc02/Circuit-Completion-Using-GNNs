spice
* NMOS Transistor
M1 Vout Vin 0 0 NMOS

* PMOS Transistor
M2 Vout VDD Vout VDD PMOS

* Voltage Source
Vin Vin 0 DC 0V
VDD VDD 0 DC 1.8V

* Output
Vout Vout 0
