spice
* SPICE Netlist for the given circuit

Q1 2 3 6 NPN

RC 2 4 4k

VBB 3 5 DC 0
VCC 4 5 DC 2.5

* Ground connection
0 5

.end
