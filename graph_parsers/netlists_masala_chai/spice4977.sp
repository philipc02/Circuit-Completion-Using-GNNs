plaintext
* NMOS Amplifier

M1 3 Vin 4 4 NMOS_MODEL
R1 3 2 33k

Vgs 4 0 DC 0

* Model definition for NMOS (example)
.model NMOS_MODEL NMOS (Level=1)

.end
