plaintext
* SPICE netlist for given schematic

* NPN Transistor
Q1 3 2 0 NPN

* Resistor
RE 2 0 RE_VALUE

* Voltage Sources
V1 2 0 AC
V2 0 0 AC

.model NPN NPN

.end
