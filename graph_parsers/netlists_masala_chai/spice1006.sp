spice
* Components
VCC 1 0 DC 2.5V
R1 1 2 500
R2 2 3 20k
R3 2 0 400
M1 2 3 0 0 NMOS

* End
