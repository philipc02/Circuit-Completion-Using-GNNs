* SPICE Netlist for Voltage Regulator Circuit

   Vin 4 0 DC 0
   RS 4 5 1000
   VZ 5 2 D
   RL 5 2 1000
   Vout 3 0

   * Models
   .model D D

   .end
