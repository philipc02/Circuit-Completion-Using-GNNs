plaintext
* SPICE Netlist
I1 5 9 DC 10mA
I2 4 7 DC 3mA
D1 2 3 DMODEL
D2 2 5 DMODEL
V1 3 0 DC 0V
.model DMODEL D

.end
