* Voltage sources
V1 3 0 DC Vin1
V2 5 0 DC Vin2

* Resistor
Rin 3 4 Rin

* Voltage-controlled voltage source
E1 2 0 3 5 A0

* Connections:
* 3 is the positive terminal of Vin1
* 5 is the positive terminal of Vin2
* 2 is Vout
* 4 connects Rin to the voltage-controlled source

.end
