plaintext
* Transistors
Q1 1 2 3 QN
Q2 2 3 3 QN
Q3 3 4 5 QN
Q4 4 6 5 QN

* Resistors
RL1 2 8 1k
RL11 8 9 1k
RL2 4 9 1k

* Capacitor
C 2 3 10u

* Current Source
I1 3 5 1mA

* Power Supplies
VCC 9 0 DC 15V
VEE 5 0 DC -15V

* Models
.model QN NPN

.end
