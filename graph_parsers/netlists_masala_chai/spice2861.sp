plaintext
* SPICE Netlist

M1 4 6 3 3 NMOS
M2 3 6 3 3 NMOS
M3 4 1 4 4 PMOS

Vn3 2 1 DC 0
Vn1 3 5 DC 0
Vn2 3 7 DC 0

Vin 6 0 DC 0

Vdd 1 0 DC VDD

* End of Netlist
