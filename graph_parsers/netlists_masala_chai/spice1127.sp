plaintext
* SPICE netlist for the given schematic

M1 3 0 2 2 NMOS

V1 3 2 DC 0.3
V2 2 0 DC 0.3

* End of netlist
