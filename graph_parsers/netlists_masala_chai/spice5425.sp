* Components
V1 3 4 AC 5 SIN(0 5 100)
R1 6 3 47
L1 2 6 50m
L2 2 2 100m
R2 2 5 10

* Ground connections
V1 4 0 0
R2 5 0

* End of netlist
.end
