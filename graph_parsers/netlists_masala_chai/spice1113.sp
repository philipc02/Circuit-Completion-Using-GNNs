plaintext
M1 drain gate source source NMOS
Vx 2 3 DC 0
Ix drain 2 DC VALUE
