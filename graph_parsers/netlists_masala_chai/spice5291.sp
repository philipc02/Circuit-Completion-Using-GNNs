spice
* SPICE netlist
R1 3 7 100
R2 2 4 47
R3 5 6 22
V1 A B DC 0
* End of netlist
