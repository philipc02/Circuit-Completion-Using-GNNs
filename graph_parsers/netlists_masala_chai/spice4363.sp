spice
* PMOS Transistors
M1 4 3 5 5 PMOS
M2 2 4 5 5 PMOS

* Current Source
IQ 5 6 DC VALUE

* Resistors
RD1 4 6 RD
RD2 2 6 RD

* Voltage Nodes
V+ 5 0 DC VDD
V- 6 0 DC VSS

* End of netlist
