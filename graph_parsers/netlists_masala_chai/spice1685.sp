spice
* NMOS Transistors
M1 2 4 1 1 NMOS
M2 2 3 2 2 NMOS

* Voltage Sources
VDD 5 0 DC VDD_value
Vin 4 0 DC Vin_value
Vb 3 0 DC Vb_value

* Resistor
Rs 4 2 Rs_value

* Capacitors
CGD1 2 5 CGD1_value
CGD2 2 3 CGD2_value
CGS1 2 4 CGS1_value
CGS2 2 3 CGS2_value
CDB1 4 1 CDB1_value
CDB2 2 0 CDB2_value
CSB1 2 3 CSB1_value
CSB2 2 2 CSB2_value

* End of Netlist
