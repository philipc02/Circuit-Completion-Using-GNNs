spice
* Netlist for the given circuit diagram

VCC 9 2 DC 15

Q1 9 7 8 NPN

R1 9 7 1k
R2 7 2 4.7k
R3 9 3 2.2k
R4 8 2 4.7k

C1 2 8 10n
C2 8 2 10n
C3 7 2 100n
C4 3 6 100n
C5 8 4 10n

L1 8 2 1m

.end
