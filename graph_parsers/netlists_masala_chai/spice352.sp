plaintext
* SPICE Netlist for the schematic

* Voltage Source
Vs 1 2 DC 0

* Resistors
Rs 4 7 Zs
R11a 8 2 Z11a
R11f 9 2 Z11f
R22a 6 2 Z22a
R22f 5 3 Z22f

* Load
RL 7 2 ZL

* Current Sources
Ii 2 5 DC i_i
If 5 6 DC i_f

.END
