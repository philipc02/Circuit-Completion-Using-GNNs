plaintext
* NMOS Transistors
M1 4 2 7 7 NMOS
M3 3 2 6 6 NMOS

* PMOS Transistor
M2 5 2 4 4 PMOS

* Current Source
IREF 8 4 DC 0.5mA

* Voltage Source
VDD 8 6 DC 3V

* Resistor
R1 5 6 1k

* Model Definitions (Example)
.model NMOS nmos
.model PMOS pmos
