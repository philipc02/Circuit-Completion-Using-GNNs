plaintext
* SPICE netlist

M1 3 A 0 0 NMOS
M2 2 B 3 3 NMOS
M3 5 C 4 4 PMOS
M4 4 D 0 0 PMOS

Vout 2 0 DC 0
