spice
* SPICE netlist for the circuit

V1 1 4 DC 1V
V2 3 0 DC 1V
V3 2 0 DC -1.5V
MN1 3 3 4 4 NMOS
I1 3 2 DC 1mA

* End of netlist
