plaintext
* SPICE netlist for transistor circuit
Q1 6 5 2 NPN
Q2 2 4 3 NPN

* Node voltage sources
VCC 5 0 DC 10
VG 6 0 DC 5
VEE 3 0 DC -10

* End of netlist
