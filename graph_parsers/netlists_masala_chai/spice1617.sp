spice
* Transistor M3 (NMOS)
M3 3 3 1 1 NMOS

* Transistor M4 (PMOS)
M4 4 2 3 3 PMOS

* Current Source I1
I1 1 0 DC <value>

* Current Source I2
I2 3 0 DC <value>

* Load Resistor R_L
RL 2 0 <value>

* Voltage Source V_DD
VDD 4 0 DC <value>

* Analysis Commands
*.op
*.end
