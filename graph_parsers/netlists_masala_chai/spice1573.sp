plaintext
* SPICE netlist for the given circuit

RRC1 3 4 RC
RRC2 3 2 RC

I1 4 0 DC I1
I2 2 0 DC I2

VCC 3 0 DC VCC

* End of netlist
