spice
* SPICE netlist for the given circuit

* Inductors
L1 7 3 8u
L2 3 5 4u

* Resistors
R1 3 6 10k
R2 5 4 10k
R3 4 2 4.7k

* Voltage input and output
Vin 7 0 DC 0
Vout 4 0 DC 0

* Ground
Vgnd 6 2 DC 0

* End of netlist
