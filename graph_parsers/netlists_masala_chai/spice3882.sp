spice
* BJT Amplifier Circuit
Q1 2 4 5 QNPN

VBB 4 6 DC 0
VCC 2 3 DC 2.5

RE 5 6 2k

.model QNPN NPN
