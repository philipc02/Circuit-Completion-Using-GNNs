* SPICE Netlist
V1 4 0 DC Vp
L1 4 2 Inductor
D1 2 3 DiodeModel
D2 3 3 DiodeModel

.model DiodeModel D
