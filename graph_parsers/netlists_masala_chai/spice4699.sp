spice
* Circuit Netlist
V1 4 3 DC 5V
R1 4 2 1k
D1 2 3 D
.model D D
