spice
Vs 1 0 DC 10
D1 1 2 DiodeModel
RL 2 0 100
.model DiodeModel D
