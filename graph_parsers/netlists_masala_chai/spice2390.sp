* NMOS Transistors
M1 N3 N6 0 0 NMOS
M2 N3 N8 0 0 NMOS
M3 N3 N4 N5 N5 NMOS
M4 0 N5 N5 N5 NMOS
M5 N3 N2 N5 N5 NMOS
M6 N20 N3 N5 N5 NMOS
M13 N2 N3 0 0 NMOS
M14 0 N2 0 0 NMOS

* PMOS Transistors
MB1 N3 N24 N6 N6 PMOS
MB6 N3 N24 N16 N16 PMOS
M7 N20 N24 N2 N2 PMOS
M8 N20 N24 N22 N22 PMOS
M9 N20 N2 N2 N2 PMOS
M10 N22 N3 N2 N2 PMOS
M11 0 N23 N2 N2 PMOS
M12 0 N22 N2 N2 PMOS

* Capacitors
CC1 N2 N20 1u
CC2 N2 N22 1u
CC3 N2 N3 1u

* Voltage Sources
VIN+ N6 0 DC V+
VIN- N8 0 DC V-
VDD N23 0 DC VDD
VSS 0 N5 DC VSS
VBIAS1 N2 0 DC VBIAS1
VBIAS2 N24 0 DC VBIAS2
VBIAS4 N16 0 DC VBIAS4
VCMFB N4 0 DC VCMFB

.END
