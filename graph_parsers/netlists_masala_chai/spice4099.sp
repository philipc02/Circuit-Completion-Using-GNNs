plaintext
* SPICE Netlist

VDD 7 0 DC 9V
Vi 8 6 DC 0V

R1 7 2 R1
RD 2 3 RD
R2 5 4 R2
RS 4 6 0.5k

CC 8 5 CC

M1 3 5 6 6 NMOS

* End of Netlist
