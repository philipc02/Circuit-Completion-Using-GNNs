* Current Sources
I1 9 4 In1_Vc1
I2 4 8 In2_Vc2
I3 7 4 In3_Vc3
I4 5 2 In4_Vc4
Is 9 0 Is/2

* Voltage Source
V1 9 0 V1

* Resistors
R1 4 7 Rc1
R2 7 0 Rc2
R3 4 5 Rc3
R4 6 5 Rc4
RL 2 3 RL
