plaintext
* SPICE Netlist
V1 6 7 DC 0
R1 6 2 0
R2 5 3 0
V2 6 7 DC 200mA
