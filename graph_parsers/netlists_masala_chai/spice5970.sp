* Transistors
Q1 2 3 0 NMOS
Q2 4 2 4 PMOS
Q3 4 2 4 PMOS

* Current Source
I1 2 0 DC 100uA

* Voltage Source
V1 3 0 AC vsig
V2 4 0 DC 3.3V

* Resistor
R1 2 3 50

* Ground
*.END
