spice
* NMOS Amplifier Circuit
VDD 4 0 DC 15
VSS 5 0 DC -15
RG 3 2 1MEG
RD 4 3 1K
RS 5 2 3K
M1 4 3 5 5 NMOS

* Model card for NMOS
.model NMOS NMOS
.END
