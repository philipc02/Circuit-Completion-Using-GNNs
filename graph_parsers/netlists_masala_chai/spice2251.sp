spice
* NMOS circuit
M1 Vout Vn 3 3 NMOS
VDD 2 0 DC 1.8
RG Vn 2 50k
RS Vout 0 1k
