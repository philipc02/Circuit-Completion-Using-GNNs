spice
* SPICE Netlist for the given schematic

VVin 3 2 DC 0
VDD 5 0 DC VDD

RG 4 2 RG
RD 5 0 RD

C1 3 22 C1
C2 5 2 C2

MN 5 22 2 2 NMOS

.ends
