spice
* SPICE netlist

Q1 7 6 2 NPN
Q2 4 5 9 NPN

I1 7 8 DC value

RF 8 5 value
RL1 5 0 value
RE 5 9 value

ZL 4 0 value

CF 2 8 value

.END
