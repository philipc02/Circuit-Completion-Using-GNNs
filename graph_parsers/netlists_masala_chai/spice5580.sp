* Op-Amp Inverting Amplifier
* Node 0 is assumed to be ground

Vin vi 0 DC 0

* Resistors
R1 vi 2 20k
R2 2 0 20k
R3 2 4 100k

* Voltage Sources and operational amplifier
E1 4 0 2 0 1

* Output
Vout 4 vo DC 0

* End of Netlist
