plaintext
* Voltage Source for input
Vi 6 0 DC <value_of_Vi>

* Diode
D1 2 3 DiodeModel

* Collector Resistor
Rc 4 5 <value_of_Rc>

* Voltage Source for collector
Vcc 4 0 DC <value_of_Vcc>

* Output
Vo 5 0 DC
