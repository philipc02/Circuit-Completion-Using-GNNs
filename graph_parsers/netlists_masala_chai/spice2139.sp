spice
* NMOS Transistor
M1 1 3 2 2 NMOS

* Resistors
R1_R2 1 2 R_parallel
RD 1 2 RD_value

* Input voltages
Vin2 Rin2 1 Vin_value
Vin1 Rin1 3 Vin_value

* Models
.model NMOS NMOS
