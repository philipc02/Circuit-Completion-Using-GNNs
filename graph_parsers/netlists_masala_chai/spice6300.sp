plaintext
* PMOS Transistor
M1 Y VDD 4 VDD PMOS

* NMOS Transistors
M2 Y A 5 5 NMOS
M3 Y B 5 5 NMOS
M4 Y C 5 5 NMOS
M5 Y D 5 5 NMOS

* Voltage Source
VDD VDD 0 DC <value>  ; Replace <value> with the actual VDD voltage
