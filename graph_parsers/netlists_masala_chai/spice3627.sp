plaintext
* SPICE Netlist

V1 1 0 DC vi
D1 1 2 D
R1 2 4 R
V2 4 0 DC vS

.END
