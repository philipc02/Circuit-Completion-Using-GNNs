plaintext
* SPICE Netlist

* NMOS Transistor
M1 3 4 2 2 NMOS W=10u L=1u

* Capacitors
CA 4 2 10u
CB 3 2 10u

* Voltage Source
Zin 3 4 DC 5V

* End of Netlist
