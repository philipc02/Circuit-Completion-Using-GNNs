plaintext
* SPICE Netlist
R1 5 2 R1
R3 2 4 R3
Vsc 5 6 DC vsc
Vacm 3 3 DC a_cm_v_ic
