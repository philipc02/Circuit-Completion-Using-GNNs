spice
* NMOS Transistors
M7 3 4 0 0 NMOS
M8 2 3 0 0 NMOS

* Voltage Source
VTH Vout1 0 DC <Voltage_Value>

* Nodes:
* 0 - Ground
* 2 - Vout2
* 3 - Node P
* 4 - Vout1

.end
