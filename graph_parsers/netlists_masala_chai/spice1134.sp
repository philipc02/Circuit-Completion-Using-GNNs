* NMOS transistor
M1 out in 0 0 NMOS

* Voltage Source
V1 in 0 DC 1

* Resistor
R1 out 0 2k

* DC Supply
VDD out 0 DC 1.8

.model NMOS NMOS
