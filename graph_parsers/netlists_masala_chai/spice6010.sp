* SPICE Netlist

* Transistors
Q1 5 6 2 NPN
Q2 4 3 2 NPN

* Current Source
I 2 7 DC I

* Voltage Sources
V_B1 6 0 DC vB1
V_B2 3 0 DC vB2

* Resistors
RC1 5 4 RC
RC2 4 4 RC

* Connections
V_CC 5 0 DC VCC

* Ground
0 GND

.end
