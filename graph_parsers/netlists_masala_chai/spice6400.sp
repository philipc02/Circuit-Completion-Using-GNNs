* SPICE Netlist

I1 7 9 DC <current_value>

L1 7 2 <inductance_value>

C2 7 4 <capacitance_value_2>
C1 2 4 <capacitance_value_1>

M1 2 3 2 2 NMOS_MODEL

RF 3 8 <resistance_value_F>
RL 5 5 <resistance_value_L>

.END
