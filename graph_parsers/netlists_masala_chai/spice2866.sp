plaintext
* Voltage source Vn,REF
Vnref 3 0 DC

* Resistor 1/gm,REF
R1 3 5 VALUE={1/gm_REF}

* Capacitor CB
C1 5 6 CB

* Voltage source Vn1
Vn1 7 5 DC

* NMOS M1 (Drain, Gate, Source)
M1 2 7 4 4 NMOS
