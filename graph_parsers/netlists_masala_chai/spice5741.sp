spice
* NPN Transistor Circuit
VCC 1 0 DC 10
VEE 6 0 DC -10
R1 1 2 5k
R2 3 6 10k
Q1 3 2 4 NPN
VBB 7 2 DC 0

* Connections
* Collector: 1
* Base: 2
* Emitter: 3

.end
