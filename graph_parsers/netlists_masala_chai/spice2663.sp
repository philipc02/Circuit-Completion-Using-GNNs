plaintext
* NMOS Transistor
M1 X N 2 2 NMOS

* PMOS Transistors
M2 N 4 5 PMOS
M3 2 4 4 PMOS

* Current Source
IREF 5 4 DC 1mA

* Voltage Source
VX 2 3 DC 5V

* End of Netlist
.END
