plaintext
V_P 3 6 DC <value_of_VP>
r02 2 5 <value_of_r02>
r04 4 2 <value_of_r04>
M2 2 3 5 5 NMOS
