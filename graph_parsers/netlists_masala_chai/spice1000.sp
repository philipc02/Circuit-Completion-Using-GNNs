plaintext
* SPICE Netlist for the given schematic
VCC 4 0 DC 2.5V
R1 4 2 30k
RC 4 3 2k
R2 2 0 1k
RE 1 0 100
Q1 3 2 1 NPN
