* Example SPICE netlist for the given schematic
I1 5 4 DC 1A
MN1 4 3 4 4 NMOS W=1u L=1u
V1 4 0 DC 0
