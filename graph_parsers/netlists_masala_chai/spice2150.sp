plaintext
* NMOS Amplifier Circuit

M1 4 3 2 2 NMOS
RD 4 1 1k
VDD 1 0 DC 5V
Vb 3 0 DC 1.8V
Vin 2 0 AC 1V

.model NMOS NMOS (LEVEL=1)
.end
