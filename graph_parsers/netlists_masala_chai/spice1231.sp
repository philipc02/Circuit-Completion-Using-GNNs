* Transistor and Voltage Source Netlist
* PMOS Transistor M2
M2 2 2 3 3 PMOS

* NMOS Transistor M1
M1 2 1 0 0 NMOS

* Voltage Source VDD
VDD 3 0 DC VDD

* Connections:
* Node 1 is Vin
* Node 2 is Vout
* Node 3 is VDD
* Node 0 is Ground
