plaintext
V1 4 2 DC 10
R1 4 3 1k
I1 2 3 DC 0
D1 3 0 DMOD

.model DMOD D
