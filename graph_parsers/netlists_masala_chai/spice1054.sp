spice
* SPICE netlist for the schematic
VCC 5 0 DC 10V
R1 5 5 1k
R2 5 22 1k
Q1 5 3 3 NPN_MODEL
Q2 22 3 44 NPN_MODEL

.model NPN_MODEL NPN
