spice
* Transistors
M1 2 2 4 4 NMOS
M2 3 2 2 2 PMOS

* Resistors
R1 2 4 R_01
R2 2 3 R_02

* Voltage sources or other components can be added as needed
* For example, if V_in or V_out need to be defined, they can be added here
