spice
* NMOS Transistors
M1 4 1 3 3 NMOS
M2 2 2 3 3 NMOS

* Voltage Source
V1 1 0 V_B

* Current Sources
IX 4 0 DC IX
IY 2 0 DC IY

* Voltage Source Description
V_B 1 0 DC 0

* Nodes
* 1: Gate of M1
* 2: Drain of M2
* 3: Source (Ground)
* 4: Drain of M1, Gate of M2
