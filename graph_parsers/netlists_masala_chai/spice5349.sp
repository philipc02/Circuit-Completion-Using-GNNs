plaintext
* SPICE Netlist
VS 6 8 DC 3V
R1 6 5 10
R2 5 3 33
R3 3 2 33
R4 2 4 33
R5 8 9 10
