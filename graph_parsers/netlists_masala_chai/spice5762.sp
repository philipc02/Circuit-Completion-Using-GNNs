plaintext
* Transistor Amplifier Circuit

V1 4 0 DC 10
V2 3 0 DC 6.3
V3 4 0 DC 7

R1 3 3 45k
R2 4 4 1k
R3 2 2 1.5k

Q1 4 3 2 NPN

.model NPN NPN (IS=1E-15 BF=100)

.end
