plaintext
* SPICE Netlist for Schematic

* NMOS Transistor Q2
M1 2 5 22 22 NMOS

* NMOS Transistor Qeq
M2 2 4 3 3 NMOS

* Voltage Source VDD
V1 22 0 DC VDD

* End of netlist
