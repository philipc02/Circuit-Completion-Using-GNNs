plaintext
V1 2 3 DC <value>
R1 2 4 <resistance_value>
D1 4 3 <diode_model>
