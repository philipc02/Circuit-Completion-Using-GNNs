spice
I1 2 4 DC 0
Rre 2 3 re_value   ; Replace re_value with the actual value if known
RL 3 0 RL_value    ; Replace RL_value with the actual value if known
Vout 3 0
