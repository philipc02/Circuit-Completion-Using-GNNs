spice
* Differential Amplifier
M1 6 9 7 7 NMOS
M2 4 5 7 7 NMOS
RD1 6 3 RD
RD2 4 2 RD
RSS 7 10 RSS
VDD 4 0 DC <VDD_value>
Vin,CM 9 0
Vout1 3 0
Vout2 2 0
