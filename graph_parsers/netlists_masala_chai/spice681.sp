plaintext
* SPICE Netlist
Iin 3 2 DC 0
D1 3 2 Dmodel
R1 3 4 1000
VB 5 2 DC 5
Vout 4 2 DC 0

.model Dmodel D
