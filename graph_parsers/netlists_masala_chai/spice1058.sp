spice
* SPICE Netlist for the Circuit

Q1 6 3 1 NPN
Q2 5 2 6 NPN

R1 5 4 1k
R2 4 0 1k

CB 4 0 10u

VCC 5 0 DC 10V
VIN 1 0 DC 0V

.model NPN NPN
