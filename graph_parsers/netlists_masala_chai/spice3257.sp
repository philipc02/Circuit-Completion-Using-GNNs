spice
* NMOS transistor
M1 3 2 3 3 NMOS

* Resistor
RD 5 3 1000

* Capacitor
CL 3 6 1u

* Voltage source
VDD 5 0 DC 10V

* Connections
* Node 2 - Gate of M1
* Node 3 - Drain and load capacitor connection
* Node 5 - VDD and resistor RD
* Node 6 - Ground for capacitor (indicated as node 3 in the figure)

* End of netlist
