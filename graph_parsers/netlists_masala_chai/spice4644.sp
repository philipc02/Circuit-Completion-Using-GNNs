spice
* SPICE Netlist for the Circuit

Vs 6 8 DC 10V
D1 2 3 1N4001
RL 3 4 1k

* Node Assignments
* 2 - Anode of diode D1
* 3 - Cathode of diode D1 and one terminal of RL
* 4 - One terminal of RL
* 6 - Positive terminal of Vs
* 8 - Ground

.END
