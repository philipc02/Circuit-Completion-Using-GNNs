plaintext
* NMOS Transistors
M1 X Vin1 5 X MNMOS
M2 Y Vin2 2 Y MNMOS
M3 5 Vb 0 Vb MNMOS

* Resistors
RD1 3 X RD
RD2 4 Y RD

* Voltage Source
VDD VDD 0 DC <value>

* Nodes
X 3 VDD
Y 4 VDD

.ends
