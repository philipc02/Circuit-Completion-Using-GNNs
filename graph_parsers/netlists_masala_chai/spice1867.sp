plaintext
* Differential Amplifier Circuit

* Transistors
Q1 3 1 6 NPN
Q2 4 2 6 NPN

* Current Sources
I1 2 3 DC 1mA
I2 5 6 DC 1mA

* Resistors
R1 3 4 1k
R2 4 5 1k

* Voltage Sources
VCC 2 0 DC 15V

* Nodes
* 1 - Vin
* 2 - VCC
* 3 - Node connecting I1, Q1, and R1
* 4 - Node connecting Q2 and R2
* 5 - Ground
* 6 - Vout

.end
