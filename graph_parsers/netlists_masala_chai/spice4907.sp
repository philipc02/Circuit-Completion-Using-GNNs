spice
* Transistor Definitions
Q1 3 2 4 NPN
Q2 3 5 6 NPN

* Resistor Definitions
R1 3 4 <value_R1>
R2 4 6 <value_R2>

* Power Supply
VCC 3 0 <value_VCC>

* End of Netlist
