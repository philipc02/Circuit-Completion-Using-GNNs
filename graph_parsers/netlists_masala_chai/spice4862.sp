* SPICE Netlist

** Voltage Sources
V1 1 7 DC 30
Vz 7 4 DC 6.2

** Resistors
R1 5 7 680
R2 3 5 2.2k
R3 3 6 2k
R4 6 4 1k

** Transistors
Q1 5 2 4 NPN
Q2 6 5 3 NPN

** End of Netlist
