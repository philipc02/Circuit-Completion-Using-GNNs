plaintext
* SPICE Netlist

Vs 2 4 DC 0
R1 2 3
I1 3 4 DC 5mA
R2 2 4
I2 3 4 DC 12mA

.END
