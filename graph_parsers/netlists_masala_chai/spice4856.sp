spice
* SPICE Netlist
V1 3 7
R1 3 6 2
R2 6 5 100
