spice
*MOSFETS
M1 6 7 8 8 NMOS
M2 4 5 6 6 NMOS
M3 2 3 4 4 NMOS

*NET DEFINITIONS
*Net 2: Rout
*Net 3: Vb2
*Net 4: Source of M3, Drain of M2
*Net 5: Vb1
*Net 6: Source of M2, Drain of M1
*Net 7: Vin
*Net 8: Ground
