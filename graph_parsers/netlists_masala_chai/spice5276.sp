plaintext
* SPICE Netlist for the given circuit

V1 4 5 DC 15V
R1 4 2 5.6k
R2 2 3 10k
R3 3 5 3.3k

.end
