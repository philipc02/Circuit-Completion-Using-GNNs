spice
* SPICE Netlist
R1 1 3 10k
R2 3 2 20k
C2 3 2 10u
Vin 1 0 DC 0

* Define ground
Vgnd 2 0 DC 0

* Output
Vout 3 0 DC 0

.end
