* SPICE Netlist for the Given Schematic

* Transistors
Q1 3 4 5 NPN
Q2 7 4 5 NPN
Q3 2 3 4 NPN

* Resistor
R1 2 3 1k

* Voltage sources and other assumed parameters for completion
V+ 2 0 DC 10V
V- 8 0 DC 0V

* End of Netlist
