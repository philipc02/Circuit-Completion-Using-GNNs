spice
* PMOS Transistor Q2
M1 2 2 3 3 PMOS

* NMOS Transistor Q1
M2 3 2 0 0 NMOS

* Ground
V0 0 0 DC 0V
