spice
* SPICE Netlist for the given schematic

V1 5 4 DC 5V

R1 5 1 1k
R2 1 3 2.2k
R3 5 2 2.2k
R4 2 3 1.5k
RL 1 2 4.7k

*.end
