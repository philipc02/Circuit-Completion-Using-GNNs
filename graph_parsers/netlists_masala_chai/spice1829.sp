spice
* SPICE Netlist

M1 3 2 2 NMOS
I1 4 3 DC
CL 3 2 1uF
Vin Vin 2 DC

* Additional settings or control statements can be added here
