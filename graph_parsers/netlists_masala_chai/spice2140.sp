* NMOS Transistor
M1 2 3 0 0 NMOS

* Resistors
R1 1 3 R_Value_1
R2 1 0 R_Value_2
RD 2 0 R_Value_D

* Voltage Source
V1 1 0 DC V_Value

* Connections
Vout 2 0 Rout

.END
