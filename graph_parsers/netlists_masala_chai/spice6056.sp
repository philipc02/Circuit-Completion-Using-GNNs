plaintext
* Differential Pair Circuit

Q1 3 4 2 NPN
Q2 6 5 2 NPN

RC1 1 3 RC
RC2 1 6 RC

Re1 2 2 RE
Re2 2 2 RE

I 2 7 DC I

VCC 1 0 DC VCC
VEE 7 0 DC VEE

* Input connections
Vin1 4 0 DC (VCM + Vidl/2)
Vin2 5 0 DC (VCM - Vidl/2)

* Output
Vout 3 6 DC 0

* End of Netlist
