* SPICE Netlist
V1 5 0 DC 10V
V2 2 0 DC -10V
R1 5 3 1k
R2 3 2 1k
D1 3 4 D
D2 3 3 D

.model D D
.END
