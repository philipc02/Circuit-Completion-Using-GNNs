plaintext
* NMOS Amplifier Circuit

* Voltage Sources
V1 5 6 DC Vi
VDD 3 0 DC VDD

* NMOS Transistor
M1 2 5 4 4 NMOS

* Resistors
RD 3 2 RD
RS 2 4 4.5k

* Capacitors
CS 2 4 CS

* Model Definitions
.model NMOS NMOS
