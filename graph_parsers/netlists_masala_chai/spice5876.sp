* SPICE Netlist for Given Schematic

Q1 2 5 2 NPN
I1 3 2 DC I
RB 5 2 RB

* Node Definitions
* 3: VCC
* 2: Common node
* 5: Ground

.end
