spice
* SPICE Netlist
M1 2 2 5 5 NMOS
M2 4 2 6 6 PMOS
C1 3 2 C1_value
C2 2 2 C2_value
VDD 6 0 DC VDD_value
