* SPICE Netlist for Circuit
V3 6 0 DC <voltage_value_V3>
V4 2 0 DC <voltage_value_V4>

I_C11 3 5 DC <current_value>

* NMOS Transistors
M_Q3 3 6 7 7 NMOS
M_Q4 4 2 8 8 NMOS

* Models
.model NMOS NMOS
