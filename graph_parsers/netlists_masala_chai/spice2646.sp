plaintext
* SPICE Netlist

VDD 66 0 DC VDD

IREF 66 5 DC IREF

M1 5 3 5 5 NMOS W=W0
M2 3 3 5 5 NMOS W=W0
M3 3 3 5 5 NMOS W=W0
M4 3 3 5 5 NMOS W=W0
M5 3 3 5 5 NMOS W=W0
M6 3 3 5 5 NMOS W=W0

I2REF 3 2 DC 2*IREF
IREF2 3 2 DC IREF/2

.END
