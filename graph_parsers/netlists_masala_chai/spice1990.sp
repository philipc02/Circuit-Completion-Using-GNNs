spice
V1 2 0 DC 5
C1 3 0 1uF
C2 2 4 2uF
