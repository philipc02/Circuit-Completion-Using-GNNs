plaintext
* Transistor Definitions
M1 Vout Vin 2 2 NMOS
M2 Vout 3 2 3 PMOS
M3 2 4 4 4 NMOS

* Voltage Sources
Vin Vin 0 DC <input_voltage_value>
VDD 3 0 DC <supply_voltage_value>

* End of Netlist
.end
