spice
* SPICE Netlist for given schematic
R1 5 4 100k
R2 4 2 50k
Cin 2 1 50f
CL 3 1 1p
XOPAMP 4 2 3 OPAMP_MODEL
* Define where 1 is connected as ground
.end
