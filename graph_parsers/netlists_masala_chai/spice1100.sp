plaintext
* SPICE Netlist
V1 4 0 DC 1.5V
V2 3 0 DC 0.5V
M1 2 4 5 5 NMOS
