* SPICE Netlist for the given schematic

Vsig 9 2 DC 0
Rsig 2 9 1k
Q1 3 2 6 Qmodel
Rc 3 8 1k

.model Qmodel NPN
