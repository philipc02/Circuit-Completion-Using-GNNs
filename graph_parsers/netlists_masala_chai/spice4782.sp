* NPN BJT Amplifier Circuit
VCC VCC 0 DC 10V
VBB 2 0 DC <value or variable name>

Q1 VCC 2 3 NPN

RC VCC 1 910
RE 3 0 180

.model NPN NPN
