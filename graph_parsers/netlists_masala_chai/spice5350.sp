plaintext
V1 4 5 DC 1.5V
R1 4 2 56
R2 6 8 100
R3 6 7 100
R4 5 3 22
