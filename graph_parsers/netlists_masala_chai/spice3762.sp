spice
* SPICE Netlist

* Voltage Source
Vi 9 3 DC 0

* Current Source
IQ 8 10 DC 0

* Resistors
RSi 9 6 1k
Ri 7 8 10k
RG 6 3 100k
RD 5 4 10k
RL 5 2 1k

* Capacitors
CC1 6 7 10u
CG 6 3 1u
CC2 5 5 10u

* End of Netlist
