spice
   * Voltage Source
   Vs 4 6 DC <value>

   * Resistor Ri
   Ri 4 7 <value>

   * Voltage Source A''Vs
   Avs 3 5 DC <value>

   * Resistor Ro
   Ro 3 3 <value>

   * Resistor RL
   RL 3 2 <value>

   * Ground
   .node 2 6 7 5 0

   .end
