spice
* SPICE Netlist for PNP Transistor Circuit

Q1 5 4 6 2N3906

R1 3 1 10k
R2 3 4 2.2k
RE 6 1 1k
RC 2 5 3.6k

VEE 0 1 DC 10V

.END
