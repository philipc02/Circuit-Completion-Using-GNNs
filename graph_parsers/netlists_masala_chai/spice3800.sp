plaintext
* NMOS Amplifier Circuit

* Voltage Source
V1 3 6 DC Vi

* NMOS Transistor M1
M1 4 3 2 2 NMOS

* Load Resistor
RL 4 5 RL

* Ground nodes
Vgnd 2 0 DC 0
Vgnd2 5 0 DC 0
Vgnd3 6 0 DC 0

* End of Netlist
