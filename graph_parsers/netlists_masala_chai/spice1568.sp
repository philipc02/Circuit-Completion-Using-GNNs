spice
* NMOS Amplifier Circuit

M1 Vout Vin 2 NMOS
RD VDD Vout 10k
RS 2 0 1k
VDD VDD 0 DC 5V
Vin Vin 0 DC 1V

.model NMOS NMOS(LEVEL=1)

.end
