spice
* SPICE Netlist
* NMOS Transistor
M1 2 4 5 5 NMOS

* Capacitors
C1 2 3 C1
C2 4 5 C2

* Inductor
L1 5 1 L

* Resistor
R1 6 3 R

* Simulation Commands
.control
run
.endc
