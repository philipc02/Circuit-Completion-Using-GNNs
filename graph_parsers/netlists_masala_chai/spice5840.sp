plaintext
* NMOS Amplifier Circuit Netlist

VDD 2 0 DC 12V

RG1 6 5 10k
RG2 5 4 10k
RD 2 3 1k

MN1 3 6 4 4 NMOS

.END
