spice
* NMOS Transistor
M1 3 2 3 3 NMOS

* Current Source
I1 2 6 DC 1

* Capacitor
C1 3 5 1uF

* Voltage Definitions
VDD 4 6 DC 5V
VI 2 0 DC 1V

* Simulation Controls
.tran 1n 10u
.end
