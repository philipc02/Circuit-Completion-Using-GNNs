spice
* NPN BJT Circuit
VCC 3 0 DC 15V
RB 2 3 430k
RC 3 1 910
RE 1 0 100
Q1 1 2 0 NPN

.model NPN NPN
.end
