spice
* SPICE Netlist for the Laser Driver Circuit

*MOSFETs
M1 5 4 2 2 NMOS
M2 7 5 6 6 NMOS

*Resistors
RD 3 5 200      ; Replace 200 with actual value
RM 6 2 50        ; Replace 50 with actual value

*Voltage Sources
VDD 3 2 DC 5     ; Replace 5 with actual value
Vin 1 2 DC 0     ; Replace 0 with actual value

*Current Source
Iout 7 6 DC 1    ; Replace 1 with actual value

*Other devices
VF 6 2 DC 0      ; Laser forward voltage
