spice
* Circuit Description
VS 5 6 DC 10V
R1 5 4 5.6k
R2 8 3 4.7k
R3 3 2 3.3k
V1 6 7 0
