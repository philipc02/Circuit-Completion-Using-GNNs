spice
* SPICE Netlist
Vgs 5 7 DC Vgs
Vds 4 6 DC Vds
Gm 2 7 5 7 gm
Cgs 5 7 Cgs
CM 3 2 CM
RL 4 6 RL
