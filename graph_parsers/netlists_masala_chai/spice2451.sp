spice
M1 2 3 5 5 NMOS
M2 5 3 6 6 NMOS
VGS 3 6 DC <value>  ; Define appropriate voltage value for VGS
