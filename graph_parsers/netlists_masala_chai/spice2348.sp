* NMOS Transistors
M1 4 7 4 4 NMOS
M2 8 4 4 4 NMOS
M7 3 4 3 3 NMOS
M8 3 4 3 3 NMOS

* PMOS Transistors
M3 6 4 2 2 PMOS
M4 4 4 6 6 PMOS
M5 2 2 2 5 PMOS
M6 5 5 6 6 PMOS

* Current Sources
I0 4 3 DC 0
In 3 3 DC 0

* Resistor
R1 5 5 1k

* Voltage source for ground reference
V0 4 0 DC 0
