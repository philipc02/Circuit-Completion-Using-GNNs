plaintext
* SPICE netlist for the circuit
M1 Vout Zin 0 NMOS
M2 Vout Zin VDD PMOS
V1 VDD 0 DC <voltage_value>
