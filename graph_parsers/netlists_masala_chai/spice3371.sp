plaintext
* Phototransistor Circuit
Q1 2 Base 3 NPN
D1 Base 2 LightDiode

.model NPN NPN (IS=1E-14 BF=100)
.model LightDiode D (IS=1E-14)
