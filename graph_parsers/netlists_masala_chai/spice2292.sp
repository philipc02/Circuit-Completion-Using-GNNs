spice
I1 3 2 DC Iin  ; Current source Iin, positive terminal at node 3, negative terminal at ground (node 2)
R1 3 2 1k      ; Resistor of 1 kΩ between node 3 and ground (node 2)
C1 3 2 1p      ; Capacitor of 1 pF between node 3 and ground (node 2)
