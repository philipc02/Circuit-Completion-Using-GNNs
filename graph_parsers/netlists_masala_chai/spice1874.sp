* SPICE Netlist

Iin 7 0 DC 0
RC 6 6 1000
RF 5 3 1000
VCC 6 0 DC 5

Q1 2 5 3 NPN
Q2 6 2 3 NPN

Isource 3 0 DC 0

* End of Netlist
