spice
* Netlist for the given schematic

* Diode
D1 1 4 D

* Capacitor
C1 4 2 Vb

* Resistor
R1 2 5 6.8k

* Voltage Source (Ground)
V1 5 0 0

* Simulation Commands
.END
