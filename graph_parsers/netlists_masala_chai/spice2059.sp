plaintext
* SPICE netlist for the given schematic

M1 3 B 4 NMOS
M2 Vout 3 4 NMOS
M3 3 A VDD PMOS
M4 Vout 3 VDD PMOS

VDD VDD 2 DC 5V

* End of netlist
