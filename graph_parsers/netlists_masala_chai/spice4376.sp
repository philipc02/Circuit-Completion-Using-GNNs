spice
* SPICE Netlist

M1 2 v1 4 4 NMOS
M2 2 v2 4 4 NMOS
M3 3 2 V+ V+ PMOS
M4 vo 2 V+ V+ PMOS
I_Q 4 V- DC

* End of Netlist
