plaintext
* Netlist for the given circuit

Vx 1 2 DC 0
Ix 1 3 DC 0
R1 3 4 1k
D1 4 2 Ideal

.end
