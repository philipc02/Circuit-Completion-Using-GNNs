* Netlist for the given schematic

* Voltage Source
V1 3 0 DC VDD

* Capacitors
CB 8 0 <CB_value>
CS 9 6 <CS_value>

* NMOS Transistors
M1 5 0 9 9 NMOS
M2 5 6 9 9 NMOS

* PMOS Transistors
M3 3 3 5 5 PMOS
M4 3 3 8 8 PMOS

* End of netlist
