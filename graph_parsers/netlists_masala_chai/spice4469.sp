plaintext
* Transistors
Q1 6 8 5 NMOS
Q2 6 4 5 NMOS
Q3 6 2 1 NMOS

* Current Source
I1 4 9 DC 0.5A

* Resistors
RC1 5 6 1k
RC2 9 7 1k
RE 2 6 0.5k

* Voltage Sources
V1 3 9 DC 3V
V2 3 6 DC -3V

.END
