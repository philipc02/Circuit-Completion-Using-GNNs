plaintext
* SPICE Netlist

* Current Sources
I2 5 7 DC
I1 7 9 DC
I3 7 2 DC
I4 7 1 DC

* BJTs
Q1 9 2 8 QMODEL
Q2 5 1 3 QMODEL
Q3 2 4 6 QMODEL
Q4 1 3 8 QMODEL

* Model Definitions
.model QMODEL NPN
