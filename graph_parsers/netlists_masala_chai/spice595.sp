spice
* SPICE Netlist for the given schematic
IX 3 2 DC 1A
R1 3 2 1k
D1 3 2 D

.model D D
