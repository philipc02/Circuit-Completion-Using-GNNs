* NMOS Transistor
M1 2 vin 4 4 NMOS

* PMOS Transistor
M2 6 2 3 3 PMOS

* Current Sources
I1 8 3 DC VALUE
I2 3 6 DC VALUE

* Resistors
R1 3 1 VALUE
R2 3 9 VALUE

* Power Supplies
V+ 8 0 DC 5
V- 7 0 DC -5

* Input and Output
Vin vin 0 DC VALUE
Vout vO 9

* End of Netlist
.END
