plaintext
M1 4 Vin 0 0 NMOS W=W L=L
M2 3 Vb2 4 4 PMOS W=W L=L
I_D 0 3 DC
