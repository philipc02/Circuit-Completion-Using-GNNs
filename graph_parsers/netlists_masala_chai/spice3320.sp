spice
* NMOS Transistors
M0 4 5 4 4 NMOS
M1 3 2 4 4 NMOS

* PMOS Transistor
M2 3 2 2 2 PMOS

* Capacitors
C1 5 2 <value_of_C1>
C0 4 0 <value_of_C0>

* Current Source
I0 5 4 <value_of_I0>

* Resistor
R1 2 4 <value_of_R1>

* Voltage Sources
VDD 2 0 <value_of_VDD>
Vin 5 0 <value_of_Vin>

.END
