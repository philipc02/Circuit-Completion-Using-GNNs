spice
* Voltage Sources
V1   6 1 DC v1/2
V2   10 4 DC v2/2
V3   6 5 DC v1
V4   6 3 DC v2

* Current Sources
I_d1 5 7 DC id1
I_d2 7 8 DC id2

* Capacitor
C1   2 7 C1_value

* Resistor
R1   5 2 R1_value

* Ground Connections
V5   6 0 DC 0
V6   9 0 DC 0
V7   4 0 DC 0
V8   3 0 DC 0
V9   1 0 DC 0
V10  10 0 DC 0

.end
