spice
* SPICE Netlist

V1 4 2 AC 1
RS 4 3 1k
RL 3 2 1k
D1 3 2 DB

.model DB D
.end
