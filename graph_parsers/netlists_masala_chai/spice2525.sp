M2 2 3 4 4 NMOS
Vb 3 0 DC <VALUE>
Rout 2 2 <VALUE>
R_parallel 4 5 <VALUE>
