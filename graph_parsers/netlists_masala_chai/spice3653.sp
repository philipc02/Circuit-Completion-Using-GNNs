spice
V1 1 0 DC 0
V2 3 0 DC 0
R1 1 2 0.5k
R2 3 3 0.5k
D1 2 4 Dmodel
D2 3 3 Dmodel
R3 3 0 9.5k
.model Dmodel D
.END
