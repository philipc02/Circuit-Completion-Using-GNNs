plaintext
* SPICE Netlist

VDD 3 0 DC 1.8V
R1 3 1 500
R2 2 1 R2_value
RS 2 0 200
M1 3 1 2 2 NMOS_Model
.END
