plaintext
* SPICE Netlist for the circuit
V1 4 0 DC 1V
V2 5 6 DC 1.9V
Vx 3 2 DC Vx_value
Ix 3 3 DC Ix_value
M1 3 4 5 5 NMOS_MODEL
