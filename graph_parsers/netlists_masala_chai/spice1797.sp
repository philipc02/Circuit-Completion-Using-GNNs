plaintext
* SPICE Netlist
M1 2 2 3 3 NMOS
M2 4 2 3 3 NMOS
RD 4 2 50k
Iout 2 3 DC 10uA
VDD 4 0 DC 5V
Vin 2 0 DC 1V
