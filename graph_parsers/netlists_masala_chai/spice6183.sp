spice
* SPICE Netlist for the given circuit
Vs 4 0 DC 0V
R1 2 5 1k
R2 2 3 1k
XOP1 0 2 3 opamp

.model opamp OPAMP
.ends
