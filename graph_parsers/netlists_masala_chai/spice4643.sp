plaintext
* SPICE Netlist
V1 1 0 DC 10V
D1 1 2 DIODE_MODEL
RB 2 3 0.23
RL 3 0 100
.model DIODE_MODEL D()
.end
