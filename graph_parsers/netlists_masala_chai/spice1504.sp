spice
* Transistor Q1
Q1 4 Vin1 0 NPN

* Transistor Q2
Q2 3 Vin2 0 NPN

* Resistor RC (left)
RC1 2 4 1k

* Resistor RC (right)
RC2 2 3 1k

* Voltage Source VCC
VCC 2 0 DC 5V

* Voltage Source Vin1
Vin1 Vin1 0 DC 0V

* Voltage Source Vin2
Vin2 Vin2 0 DC 0V

* .model for demo purposes
.model NPN NPN
