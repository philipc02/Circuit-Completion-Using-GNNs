* Netlist for the given circuit
V_in 1 4 DC 0
r_pi 4 2 1k
I1 2 3 DC 0 g_m_v_pi
R_L 5 3 1k
R_sp 2 4 1k
Vout 5 6 DC 0
