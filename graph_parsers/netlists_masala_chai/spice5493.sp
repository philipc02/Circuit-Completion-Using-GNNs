plaintext
* Amplifier Circuit with Feedback

* Voltage Source
VCC 1 0 DC 15

* Resistors
R1 2 1 10k
R2 4 0 10k
R3 2 3 10k
R4 5 4 10k

* Capacitors
C1 2 6 10uF
C2 3 5 10uF
C3 4 0 10uF
C4 5 7 10uF
C5 8 9 10uF

* Inductors
L1 8 10 1mH
L2 9 7 1mH

* Transistor
Q1 3 4 0 NPN

* Output
VOUT 7 0

* End
