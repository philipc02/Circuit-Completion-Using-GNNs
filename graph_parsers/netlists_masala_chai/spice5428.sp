plaintext
* SPICE Netlist

Vs 0 4 AC 25 SIN(0 25 400)

R1 0 5 56
R2 4 5 22
R3 5 2 33

L1 5 6 50m
L2 2 3 50m

* Ground connection
.cn 3 0 DC 0

.end
