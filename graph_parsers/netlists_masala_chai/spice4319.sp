spice
* SPICE Netlist
M1 2 5 3 3 NMOS
Q2 3 2 4 NPN
IBias 2 4 DC
Vi 5 0 DC 0
