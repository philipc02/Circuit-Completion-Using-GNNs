spice
* Transistor Q1
Q1 6 1 9 NPN

* Transistor Q2
Q2 7 2 9 NPN

* Transistor Q3
Q3 3 4 6 PNP

* Transistor Q4
Q4 3 5 7 PNP

* Current Source IQ
I1 9 8 DC I_Q

* Voltage nodes
v1 1 0 DC (Vd/2)
v2 2 0 DC (-Vd/2)
v+ 3 0 DC V+
v- 8 0 DC V-

* End of netlist
