spice
* Transistors
Q1 6 4 2 QNPN
Q2 7 5 2 QNPN

* Resistors
R1 6 4 10k
R2 7 20 10k

* Current Sources
I1 2 0 DC 0.5mA
I2 2 22 DC 0.5mA

* Voltage Source
Vsig 4 0 DC

* Capacitor
C1 22 0 <cap_value>

* Models
.model QNPN NPN
