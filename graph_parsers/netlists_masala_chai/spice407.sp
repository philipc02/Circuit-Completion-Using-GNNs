spice
* SPICE netlist for the given schematic

V1 1 0 DC 6
V2 11 0 DC -6

R1 2 11 2400
R2 2 1 10000
R3 3 2 1100
R4 4 1 1100
R5 5 4 7000
R6 5 6 7000
R7 9 8 1400
R8 10 7 300
R9 12 1 400
R10 12 11 400
Rl 8 0 2000
R11 1 6 640
R12 5 3 640

Q1 5 2 11
Q2 6 3 5
Q3 4 4 6
Q4 7 5 1
Q5 12 6 5
Q6 8 3 2
Q7 8 9 11
Q8 6 5 11
Q9 10 11 9
Q10 9 11 10
Q11 7 7 4

.END
