spice
* SPICE Netlist
* Components

* PMOS Transistors
M3 3 7 8 8 PMOS
M4 3 6 4 4 PMOS

* Current Sources
I3 2 8 DC <value_I3>
I4 4 0 DC <value_I4>

* Voltage Supply
VDD 3 0 DC <value_VDD>

* Nodes
* 0 - Ground
* 3 - Supply (VDD)
* 4, 5, 6, 7, 8 - Other nodes as per image annotations

.end
