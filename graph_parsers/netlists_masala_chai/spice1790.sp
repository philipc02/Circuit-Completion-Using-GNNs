spice
* SPICE Netlist
VDD 5 0 DC 5V
Rin 3 0 1k
RD 5 5 1k
R1 4 2 1k
R2 2 0 2k
M1 5 3 3 3 NMOS
