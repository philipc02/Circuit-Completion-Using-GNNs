spice
* Netlist for the given circuit

V1 2 0 DC 3V
I3 4 0 DC

D1 2 4
D2 2 0

.END
