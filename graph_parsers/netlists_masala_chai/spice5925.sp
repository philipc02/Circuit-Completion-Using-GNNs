plaintext
* Transistor Definitions
M1 4 3 10 10 NMOS
M2 4 2 10 10 NMOS
M3 5 8 4 5 PMOS
M4 5 7 5 5 PMOS

* Voltage Definitions
VDD 5 0 DC VDD
VG2 2 0 DC VG2
VG3 8 0 DC VG3
VG4 7 0 DC VG4
Vi 3 0 DC Vi

* End of Netlist
