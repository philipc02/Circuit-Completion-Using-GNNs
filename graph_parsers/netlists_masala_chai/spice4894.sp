* Components
V1 4 0 AC 1
R1 4 5 1k
R2 5 0 1k
RC 2 3 1k

* Transistor
Q1 2 5 3 NPN

* Netlist ends
