spice
V1 3 4 DC 0
R1 3 2 1000
D1 2 4 D
.model D D
