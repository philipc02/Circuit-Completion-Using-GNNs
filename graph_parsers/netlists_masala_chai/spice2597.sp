plaintext
* MOS Differential Pair Circuit
M1 3 Vin,CM 2 2 NMOS L=1u W=1u
RD1 4 3 1k
RD2 6 3 1k
RSS 3 0 1k
VDD 6 0 DC 5V
