spice
* NMOS Inverter Circuit

M1 3 Vin 0 0 NMOS
RD 2 3 1k
CL 3 0 1uF
VDD 2 0 DC 5V
Vin Vin 0 DC 0V

.model NMOS NMOS (LEVEL=1)

.end
