spice
* SPICE Netlist from Schematic
Vsig 6 7 DC 0
Rsig 6 2 1k
MN1 3 2 5 5 NMOS
I1 4 3 DC 1mA
* Node 5 is connected to ground
V5 5 0 DC 0
