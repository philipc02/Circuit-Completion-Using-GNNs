spice
* SPICE netlist for the given schematic

M1 2 1 4 4 NMOS
Rout 2 0 Rout_value
Ro 2 3 Ro_value
Rs 4 0 Rs_value
Vin 1 0 DC 0

.model NMOS NMOS
