* CMOS Logic Circuit
M1 4 6 2 2 PMOS W=2W
M2 4 7 4 4 PMOS W=2W
M3 3 5 4 4 PMOS W=2W
M4 2 6 2 2 NMOS W=3W
M5 2 2 2 2 NMOS W=3W
M6 2 2 2 2 NMOS W=3W
CL 3 2 CL

VDD 7 0 DC VDD
