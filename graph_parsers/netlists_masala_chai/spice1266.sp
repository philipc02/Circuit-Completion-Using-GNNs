* NMOS Transistor: M1
M1 out Vin 2 2 NMOS

* NMOS Transistor: M2
M2 2 Vb 0 0 NMOS

* Resistor: RS
RS out 2 RS_VALUE

* Voltage Source: VDD
VDD VDD 0 DC VDD_VALUE

* Voltage Source: Vin
Vin Vin 0 DC VIN_VALUE

* Voltage Source: Vb
Vb Vb 0 DC VB_VALUE

* Output
Vout out 0

.end
