spice
* SPICE Netlist
V1 3 2 DC 120
R1 3 4 11k
R2 4 2 1k
RV 4 2 54k
* End of Netlist
