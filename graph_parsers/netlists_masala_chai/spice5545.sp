* Circuit Netlist

V1 7 5 DC 10

R1 7 1 1k
R2 1 5 1.2k
R3 7 2 9.1k
R4 2 5 11k
R5 1 2 2k

*.end
