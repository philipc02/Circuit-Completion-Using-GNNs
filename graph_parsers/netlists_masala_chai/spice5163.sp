spice
* Operational Amplifier Circuit
R1 Vin 2 R1_value
R2 2 3 R2_value
R3 2 0 R3_value
C1 2 3 C_value
C2 3 0 C_value
* Ideal Op-amp
XU1 3 2 3 OPAMP

* Voltage Source
Vin Vin 0 DC Vin_value

* End of netlist
