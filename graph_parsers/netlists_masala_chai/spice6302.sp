plaintext
* Netlist Generated from the Schematic
* NMOS Transistor: M1
M1 V_O V_I V_C V_C NMOS

* Capacitor: C1
C1 V_O 0 C

* Voltage Supply
V_VDD V_C 0 VDD

* Input Voltage
V_VI V_I 0 0

* Model Definition (Example NMOS)
.model NMOS NMOS(Level=1)

* End of Netlist
