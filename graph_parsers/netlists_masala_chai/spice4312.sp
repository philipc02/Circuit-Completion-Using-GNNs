plaintext
* SPICE Netlist
* Qx C B E
Q1 6 6 6 NPN
Q2 6 2 2 NPN
Q3 4 4 5 NPN
Q4 7 4 3 NPN
Q5 5 4 2 NPN

I_Q 6 0 DC 0.1

V+ 4 0 DC 5
V- 0 6 DC -5

* End of Netlist
