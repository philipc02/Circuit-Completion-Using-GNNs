plaintext
* Feedback Network Circuit

* Current Source
I1 6 3 DC 0

* Voltage Source
V1 4 0 DC 0

* Resistors
Rzi 3 0 z_i
Rzo 2 4 z_o
RF 3 2 R_F
RL 2 7 R_L

* Control Voltage Source
E1 4 0 3 0 -alpha

.end
