plaintext
* SPICE Netlist for the given schematic
V1 10 4 DC 15V
R1 10 9 13.7k
R2 3 2 700
Q1 6 8 4 QNPN
Q2 9 6 4 QNPN
Q3 2 7 3 QNPN
.model QNPN NPN

.end
