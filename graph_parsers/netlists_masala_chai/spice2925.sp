plaintext
* SPICE Netlist

M1 3 4 2 2 NMOS
M2 2 6 2 2 NMOS
VDD 3 0 DC VDD
VX 2 0 DC VX
RD 3 5 RD
C1 5 6 C1
C2 6 0 C2

* End of Netlist
