plaintext
Vin 2 4 DC 0V
R1 2 3 1k
D1 3 4 Dmodel
D2 5 3 Dmodel
Vsource 4 5 DC 700mV

.model Dmodel D
