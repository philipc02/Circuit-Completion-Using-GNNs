plaintext
* Op-amp circuit
R1 1 3 20k
R2 3 2 100k
R3 2 6 20k
XOP 2 1 7 OPAMP
V1 7 5 DC 0
