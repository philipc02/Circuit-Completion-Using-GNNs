spice
* Netlist for the schematic
M1 3 4 2 2 NMOS
C1 3 4 1uF
C2 4 2 1uF
I1 3 0 1mA
VDD 3 0 DC 5V
Vout 3 0
