plaintext
* NMOS Transistors
M1 3 8 7 7 NMOS
M2 4 9 8 8 NMOS
M3 3 3 3 3 NMOS
M4 4 4 3 3 NMOS

* PMOS Transistors
M5 2 2 22 22 PMOS
M6 6 5 4 4 PMOS
M7 5 2 8 8 PMOS
M8 7 2 9 9 PMOS

* Current Source
IREF 3 7 DC I_REF

* Capacitor
CC 5 4 C_C

* Voltage Sources
VDD 22 0 DC VDD
VSS 0 3 DC VSS

* Output
VOUT 5 0
