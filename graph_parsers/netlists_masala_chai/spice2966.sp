* Basic Amplifier Circuit

V1 4 0 DC Vin
RS 4 2 1k
RF 2 3 10k
RD 3 VDD 10k
M1 3 5 0 0 NMOS

* Connections
X 2
Vout 3

* Ending
.end
