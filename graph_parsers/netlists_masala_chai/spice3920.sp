plaintext
* SPICE Netlist for the given schematic
Vplus 8 5 DC 2.5
Vminus 7 6 DC -2.5
R1 5 2 <value>
R2 2 3 <value>
RE 5 4 2k
RC 3 7 <value>
Q1 2 3 4 NPN
