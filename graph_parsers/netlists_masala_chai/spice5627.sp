spice
* Simple RC Circuit with Diode
V1 1 4 DC 5V
R1 1 3 1000
D1 3 2 D
V2 2 4 DC 0V
