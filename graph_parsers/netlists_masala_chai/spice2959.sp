spice
* Netlist for the provided schematic

MN1 2 4 5 5 NMOSModel
R1 3 2 1k
R2 5 0 1k
C1 4 2 1u

* NMOS Model
.model NMOSModel nmos

.END
