spice
* SPICE Netlist for the schematic
Vi 2 7 DC
RG 2 3 5k
Mnmos 3 2 7 7 NMOS L=1u W=1u
Gm 3 4 2 0 gm
Ro 3 4 50k
RD 5 3 10k
RL 6 5 10k
Rin 7 3 1k
