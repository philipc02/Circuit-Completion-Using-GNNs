spice
* SPICE Netlist

M1 4 3 6 6 NMOS
M2 5 3 2 2 NMOS

I1 7 4 DC IBIAS

* End of Netlist
