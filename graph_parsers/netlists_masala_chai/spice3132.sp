spice
* List of components
I1 4 8 DC 25uA
R1 8 7 8k
M12 7 8 0 0 NMOS L=40n W=8u
M1 2 5 7 7 PMOS L=40n W=600u
M2 3 5 6 6 PMOS L=40n W=600u
M11 6 7 0 0 NMOS L=40n W=8u
VDD 4 0 DC

* Voltage sources
V1 2 0 DC 0
V2 3 0 DC 0
V3 5 0 DC 300mV

.end
