plaintext
* SPICE Netlist for the given schematic

Q1 2 8 6 NPN
Q2 5 2 7 NPN

Iin 8 6 DC 1A
VCC 5 0 DC 10V

RC 5 2 1k
RF 6 0 1k

* Additional device connections and model definitions would go here, if any.
* End of Netlist
