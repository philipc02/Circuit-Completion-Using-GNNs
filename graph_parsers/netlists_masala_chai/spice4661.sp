* SPICE Netlist

Vin 3 0 DC 0V
RS 3 4 1k
D1 3 5 D
D2 4 2 D
Vout 2 0

.model D D

.end
